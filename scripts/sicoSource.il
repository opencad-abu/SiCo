; Generated by tools/utility/skill_loader.py --write; edit the manifest/sources.
; Source-only. Per-file contracts retain successful members across retries.
let((entryDirectory)
  entryDirectory=strcat("/" buildString(reverse(cdr(reverse(
    parseString(simplifyFilename(get_filename(piport) t) "/")))) "/"))
  load(strcat(entryDirectory "/sicoSkillLoader.ils"))
  SICO_sourceRequire("core" "c1572963087584658ced01ff0f3a7a1dd9ab942db06d903ed7fd6ec4d35efd72" '(
    ("tools/common/skill" "SICO_environment.il" "02e39a3df4de1424b4e12ca696f47b67940c32e386724f1f088f618cd533b76c"
      (SICO_environmentValue SICO_flowEnvironmentValue SICO_envValue)
      ()
      (sicoEnvironmentVersion)
      ())
    ("tools/common/skill" "SICO_installation.il" "010053edcd29627e3ac523450eca278466fe7a432d85afbbf25a88aa4fb06642"
      (SICO_installationRoot SICO_installationCanonicalPath SICO_installationContainedP
       SICO_installationPath SICO_iconPath SICO_installedPython SICO_installationSourceP)
      ()
      (sicoInstallationVersion)
      ())
    ("tools/common/skill" "SICO_state.il" "5fb360249fda9e7e5951f7eb33fdad184ae178ea78d4b96fdd51a6baa84a6623"
      (SICO_stateInitialize SICO_stateQuote SICO_stateCommand SICO_stateResponse SICO_stateError
       SICO_stateDirectory SICO_stateLaunchDirectory SICO_stateEnvironment SICO_stateRevision)
      ((SICO_stateRevision "20261020.sico.state.v5"))
      (sicoStateVersion)
      ())
    ("tools/common/skill" "SICO_commands.il" "a74ffc4897e5d872ba68c35f34f8caef68f4b54b39505e2389df05797087ee78"
      (SICO_commandTool SICO_commandElfP SICO_commandNative SICO_commandQuote SICO_commandInvocation
       SICO_commandsRevision)
      ((SICO_commandsRevision "20260924.sico.commands.v4"))
      (sicoCommandsVersion)
      ())
    ("tools/common/skill" "SICO_guiProtocol.il" "f2d0b96b8514cf461529d0c32aa7a153c532d6e2251bb97061b4b3831a72971f"
      (SICO_guiProtocolValidField SICO_guiProtocolWrite SICO_guiProtocolRead SICO_guiPythonEnvironment
       SICO_guiPythonLaunchCommand SICO_guiProtocolRevision)
      ((SICO_guiProtocolRevision "20260814.cadgui.v1"))
      (sicoGuiProtocolVersion)
      ())
    ("tools/common/skill" "SICO_toml.il" "98adef5bb022f888bbbaa8d811c325fef9d990e779630839d57e9b34771f2681"
      (SICO_initializeWorkingDir SICO_tomlString SICO_tomlBool SICO_shellQuote SICO_absolutePath
       SICO_tempDir SICO_tempPath SICO_tempEnvironment SICO_fileStem SICO_logo SICO_toolsRoot
       SICO_pythonLibraryPath SICO_nativeEntry SICO_backendCommand SICO_tomlWriteSection
       SICO_tomlWriteString SICO_tomlWriteStringList SICO_tomlWriteBool SICO_tomlRevision)
      ((SICO_tomlRevision "20260922.sico.temp.v6"))
      (sicoTomlVersion)
      ())
    ("scripts" "sicoLoaderApi.il" "357331847293276fbf90b91d15986f810e2d63a006cd3415c19589ee1a6290ae"
      (aiResolveRoot aiLoadFrontend aiLoaderRevision sicoLoaderRevision drcLoaderRevision
       lvsLoaderRevision rceLoaderRevision lefLoaderRevision)
      ((aiLoaderRevision "20260924.ai.loader.v34") (sicoLoaderRevision "20260924.sico.loader.v6"))
      (sicoSourceApiVersion)
      ())
  ))
)
