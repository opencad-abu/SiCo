; Generated by tools/utility/skill_loader.py --write; edit the manifest/sources.
; Source-only. Per-file contracts retain successful members across retries.
let((entryDirectory)
  entryDirectory=strcat("/" buildString(reverse(cdr(reverse(
    parseString(simplifyFilename(get_filename(piport) t) "/")))) "/"))
  load(strcat(entryDirectory "/sicoSkillLoader.ils"))
  SICO_sourceRequire("core" "4ae8565718d781f23195bc692e901c4f653317c83c7cb722148d1522dba45bf2" '(
    ("tools/common/skill" "SICO_environment.il" "02e39a3df4de1424b4e12ca696f47b67940c32e386724f1f088f618cd533b76c"
      (SICO_environmentValue SICO_flowEnvironmentValue SICO_envValue)
      ()
      (sicoEnvironmentVersion)
      ()
      ())
    ("tools/common/skill" "SICO_installation.il" "e4c5c63e63159f84763d11cbaebd83445a1f484dc760c3b2cabe652bd78cb375"
      (SICO_installationRoot SICO_installationCanonicalPath SICO_installationContainedP
       SICO_installationPath SICO_iconPath SICO_installedPython SICO_installationSourceP)
      ()
      (sicoInstallationVersion)
      ()
      ())
    ("tools/common/skill" "SICO_state.il" "97518cc58358c9583b4407d67faf752e0ea116aebcb4b4a73827403909a00bdb"
      (SICO_stateInitialize SICO_stateQuote SICO_stateCommand SICO_stateResponse SICO_stateError
       SICO_stateDirectory SICO_stateLaunchDirectory SICO_stateEnvironment SICO_stateRevision)
      ((SICO_stateRevision "20261024.sico.state.v6"))
      (sicoStateVersion)
      ()
      ())
    ("tools/common/skill" "SICO_commands.il" "0e5832c9d6ab20f109157d39245c7d29c2baade1abf05b981951e49d91bfe6a1"
      (SICO_commandTool SICO_commandElfP SICO_commandNative SICO_commandQuote SICO_commandInvocation
       SICO_commandsRevision)
      ((SICO_commandsRevision "20261029.sico.commands.v5"))
      (sicoCommandsVersion)
      ()
      ())
    ("tools/common/skill" "SICO_guiProtocol.il" "f2d0b96b8514cf461529d0c32aa7a153c532d6e2251bb97061b4b3831a72971f"
      (SICO_guiProtocolValidField SICO_guiProtocolWrite SICO_guiProtocolRead SICO_guiPythonEnvironment
       SICO_guiPythonLaunchCommand SICO_guiProtocolRevision)
      ((SICO_guiProtocolRevision "20260814.cadgui.v1"))
      (sicoGuiProtocolVersion)
      ()
      ())
    ("tools/common/skill" "SICO_toml.il" "dece05c6dd1c92e6b9d30324377daf86899163b29f8b54ccc5712bb9bd42e7b3"
      (SICO_initializeWorkingDir SICO_tomlString SICO_tomlBool SICO_shellQuote SICO_absolutePath
       SICO_tempDir SICO_tempPath SICO_tempEnvironment SICO_fileStem SICO_logo SICO_toolsRoot
       SICO_pythonLibraryPath SICO_nativeEntry SICO_backendCommand SICO_tomlWriteSection
       SICO_tomlWriteString SICO_tomlWriteStringList SICO_tomlWriteBool SICO_tomlRevision)
      ((SICO_tomlRevision "20261024.sico.temp.v7"))
      (sicoTomlVersion)
      ()
      ())
    ("scripts" "sicoLoaderApi.il" "357331847293276fbf90b91d15986f810e2d63a006cd3415c19589ee1a6290ae"
      (aiResolveRoot aiLoadFrontend aiLoaderRevision sicoLoaderRevision drcLoaderRevision
       lvsLoaderRevision rceLoaderRevision lefLoaderRevision)
      ((aiLoaderRevision "20260924.ai.loader.v34") (sicoLoaderRevision "20260924.sico.loader.v6"))
      (sicoSourceApiVersion)
      ()
      ())
  ))
)
