; Generated by tools/utility/skill_loader.py --write; edit the manifest/sources.
; Source-only. Per-file contracts retain successful members across retries.
let((entryDirectory)
  entryDirectory=strcat("/" buildString(reverse(cdr(reverse(
    parseString(simplifyFilename(get_filename(piport) t) "/")))) "/"))
  load(strcat(entryDirectory "/../sicoSkillLoader.ils"))
  load(strcat(entryDirectory "/../../tools/common/skill++/LSF.ils"))
  load(strcat(entryDirectory "/common_gui.ils"))
  SICO_sourceRequire("flow" "496a2b1a7271bf862823d45ec7c470c79f484b04d8289d0f69ab722ed865f5bb" '(
    ("tools/common/skill" "SICO_profile.il" "54ddfc943e5a9283ad710d2a0fc92d32c91408e2b800284410ac333594869136"
      (SICO_profileFlowKey SICO_profileRegisterAdapter SICO_profileAdapter SICO_profileDataValue
       SICO_profileFormValue SICO_profileSetFormValue SICO_profilePathValue SICO_profileCollectFields
       SICO_profileApplyFields SICO_profileSetLoadData SICO_profileDefaultPath SICO_profilePythonExe
       SICO_profilePythonEntry SICO_profileLaunchCommand SICO_profileMessage SICO_profilePath
       SICO_profileStringList SICO_profileResolvedPathP SICO_profileSamePathP SICO_profilePathStates
       SICO_profilePreserveRawPaths SICO_profileWriteValue SICO_profileArrayPathP
       SICO_profileWriteEntryValue SICO_profileWriteKey SICO_profileEntrySection SICO_profileEntryLessP
       SICO_profileUniqueEntries SICO_profileWriteEntries SICO_profilePersistentEntryP
       SICO_profilePersistentEntries SICO_profileWrite SICO_profileCollect SICO_profileApply
       SICO_profileSaveTo SICO_profileSaveCB SICO_profileSaveAsCB SICO_profileLoadCB
       SICO_profileRevision)
      ((SICO_profileRevision "20261022.profile.environment.v6"))
      (sicoProfileVersion)
      ()
      ())
    ("tools/common/skill" "SICO_envOptions.il" "3e6be1bb82da6e513d6ad6e0a0904621b3944beba14aca8eb8100cc3d18a68e4"
      (SICO_parseEnvPairs SICO_envPairNames SICO_envPairValue SICO_envOptionsRevision)
      ((SICO_envOptionsRevision "20260924.flow.environment.v2"))
      (sicoEnvOptionsVersion)
      ()
      ())
    ("tools/common/skill" "SICO_batchAdapter.il" "ac1764cffc06b1259bcf761b69a56d9e64540cc114d7faafd96950f612e5705b"
      (cadBatchFlowKey cadBatchRegisterFlowAdapter cadBatchFlowAdapter cadBatchAdapterCallback
       cadBatchAdapterCall cadBatchFlowPairedP cadBatchAdapterEnterMultiple cadBatchAdapterLeaveMultiple
       cadBatchAdapterOpenResult cadBatchAdapterPythonExe cadBatchAdapterRevision)
      ((cadBatchAdapterRevision "20260812.common.v1"))
      (cadBatchAdapterVersion)
      ()
      ())
    ("tools/common/skill" "SICO_batchGui.il" "2936bed6bb24bd743d33cf4a1bce935dd75ff56fcaba49c631bf9272e04ab1f4"
      (cadBatchPairedFlowP cadBatchMessage cadBatchCreateLcvEditor cadBatchCreateSyncButtons
       cadBatchCreateTaskReport cadBatchCreateTaskContextMenu cadBatchCreateTaskButtons
       cadBatchCreateTaskLayout cadBatchMultipleP cadBatchScopeCB cadBatchBindForm
       cadBatchGuiSharedRevision)
      ((cadBatchGuiSharedRevision "20260812.common.v1"))
      (cadBatchGuiVersion)
      ()
      ())
    ("tools/common/skill" "SICO_batchRows.il" "83b4c64e1dc5179c541f37d47c1ab5d04dabb577cc8836869e5cb2e5d51c2035"
      (cadBatchFieldValue cadBatchCopyLcvCB cadBatchEditorValues cadBatchSetEditorValues
       cadBatchSetDesignValues cadBatchDesignValues cadBatchRowValidP cadBatchRowKey
       cadBatchDuplicateRowP cadBatchReplaceAt cadBatchRemoveAt cadBatchIndexValidP cadBatchRefreshReport
       cadBatchSelectedIndex cadBatchTaskReportCB cadBatchTaskDoubleClickCB cadBatchTaskContextMenuCB
       cadBatchDeleteSelectedMappingCB cadBatchAddUpdateCB cadBatchRemoveCB cadBatchClearCB
       cadBatchValidateTasks cadBatchRowsRevision)
      ((cadBatchRowsRevision "20260812.common.v1"))
      (cadBatchRowsVersion)
      ()
      ())
    ("tools/common/skill" "SICO_batchCore.il" "a9c5ce63f8cebe7877fd384b03e9732ab40ee45cefbcf21b4aaa0f45003e1ac8"
      (cadBatchDispatchStart cadBatchSafeToken cadBatchNewId cadBatchCreateRoot cadBatchMakeSpec
       cadBatchSpecSet cadBatchTaskId cadBatchJobName cadBatchPythonExe cadBatchPythonEntry
       cadBatchControllerCommand cadBatchWriteManifest cadBatchBuildMeta cadBatchSpecById
       cadBatchSpecsIndependentP cadBatchLaunch cadBatchCancel cadBatchIpcDataHandler
       cadBatchIpcErrHandler cadBatchIpcPostFunc cadBatchCoreRevision)
      ((cadBatchCoreRevision "20261024.batch.commands.v5"))
      (sicoBatchCoreVersion)
      ()
      ())
    ("tools/common/skill" "SICO_batchMonitor.il" "fa8de019ae9b78e80f9b10e0057834eb664b1205ae9a53d8820c39d46a939b48"
      (cadBatchMonitorFormValidP cadBatchMonitorDropStaleForm cadBatchMonitorReadRows
       cadBatchMonitorInitialRows cadBatchMonitorChoices cadBatchMonitorSummary
       cadBatchMonitorSelectedRow cadBatchMonitorSelectedSpec cadBatchMonitorOpenResultCB
       cadBatchMonitorOpenLogCB cadBatchMonitorCancelCB cadBatchMonitorRefreshCB cadBatchMonitorRefresh
       cadBatchMonitorTimer cadBatchMonitorDisplay cadBatchMonitorRevision cadBatchMonitorAuditRevision)
      ((cadBatchMonitorRevision "20261024.form.lifecycle.v2") (cadBatchMonitorAuditRevision
       "20261024.flow.audit.v2"))
      (sicoBatchMonitorAuditVersion)
      ()
      ())
    ("tools/common/skill++" "BATCHGUI.ils" "03469891ea04c332e533749c19e386d297f3a65d4f6c17700a7f79074b1438ef"
      (makeBatchControls makeBatchParallelCells cadBatchGuiRevision)
      ((cadBatchGuiRevision "20260812.common.v1"))
      ()
      (BATCHGUI)
      (makeBatchControls makeBatchParallelCells))
    ("tools/common/skill++" "PROFILEGUI.ils" "52ca0cd1b7a1e7ecb7967b59727bfe6f025b4edbdcf5008f20d702436479a26d"
      (makeProfileControls SICO_profileGuiRevision)
      ((SICO_profileGuiRevision "20260818.profile.gui.v2"))
      ()
      (PROFILEGUI)
      (makeProfileControls))
    ("tools/utility/skill" "UI_messageApp.il" "05e485cc50d41adb89e9601cff06ed635e38c0a84dfc20060a7b98e072aa916a"
      (GUI_messageApp)
      ()
      (sicoGuiMessageAppVersion)
      ()
      ())
    ("tools/utility/skill" "UI_askApp.il" "4966b5203726401f46b339ce43ca397de637827642c3d019928c60f9d603155d"
      (GUI_askApp)
      ()
      (sicoGuiAskAppVersion)
      ()
      ())
    ("tools/utility/skill" "UI_windowIcon.il" "bb5dc30b48cd1b7e162df6375b8052260aa8930b0b44bfa07f7ce6714eef6c45"
      (SICO_windowIconRevision SICO_windowIconBrand SICO_windowIconPath SICO_windowIcon
       SICO_setWindowIcon)
      ((SICO_windowIconRevision "20261024.sico.flow.icon.v2"))
      (sicoWindowIconVersion)
      ()
      ())
    ("tools/utility/skill" "UI_flowLog.il" "a4462b093f44066d21c29428a0204e6f83d328bd1bd2fd70875b6194d66242df"
      (GUI_flowLogBrand GUI_flowLogWindowClosed GUI_flowLogCreate GUI_flowLogOpenRequest GUI_flowLogOpen
       GUI_flowLogShow GUI_flowLogClose GUI_flowLogRevision)
      ((GUI_flowLogRevision "20261024.flow.log.owned.v3"))
      (sicoFlowLogVersion)
      ()
      ())
  ))
)
