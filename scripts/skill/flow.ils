; Generated by tools/utility/skill_loader.py --write; edit the manifest/sources.
; Source-only. Per-file contracts retain successful members across retries.
let((entryDirectory)
  entryDirectory=strcat("/" buildString(reverse(cdr(reverse(
    parseString(simplifyFilename(get_filename(piport) t) "/")))) "/"))
  load(strcat(entryDirectory "/../sicoSkillLoader.ils"))
  load(strcat(entryDirectory "/../../tools/common/skill++/LSF.ils"))
  load(strcat(entryDirectory "/common_gui.ils"))
  SICO_sourceRequire("flow" "7f64835ffc90727a29edcc249edd2749e9800e70e492a8578c0d575340b987c0" '(
    ("tools/common/skill" "SICO_profile.il" "8248a31608d009d0a7fbbc0e5b0404fcb3426ac905fe79b87f4a7aa8823084b5"
      (SICO_profileFlowKey SICO_profileRegisterAdapter SICO_profileAdapter SICO_profileDataValue
       SICO_profileFormValue SICO_profileSetFormValue SICO_profilePathValue SICO_profileCollectFields
       SICO_profileApplyFields SICO_profileSetLoadData SICO_profileDefaultPath SICO_profilePythonExe
       SICO_profilePythonEntry SICO_profileLaunchCommand SICO_profileMessage SICO_profilePath
       SICO_profileStringList SICO_profileResolvedPathP SICO_profileSamePathP SICO_profilePathStates
       SICO_profilePreserveRawPaths SICO_profileWriteValue SICO_profileArrayPathP
       SICO_profileWriteEntryValue SICO_profileWriteKey SICO_profileEntrySection SICO_profileEntryLessP
       SICO_profileUniqueEntries SICO_profileWriteEntries SICO_profilePersistentEntryP
       SICO_profilePersistentEntries SICO_profileWrite SICO_profileCollect SICO_profileApply
       SICO_profileSaveTo SICO_profileSaveCB SICO_profileSaveAsCB SICO_profileLoadCB
       SICO_profileRevision)
      ((SICO_profileRevision "20261022.profile.environment.v6"))
      (sicoProfileVersion)
      ())
    ("tools/common/skill" "SICO_envOptions.il" "3e6be1bb82da6e513d6ad6e0a0904621b3944beba14aca8eb8100cc3d18a68e4"
      (SICO_parseEnvPairs SICO_envPairNames SICO_envPairValue SICO_envOptionsRevision)
      ((SICO_envOptionsRevision "20260924.flow.environment.v2"))
      (sicoEnvOptionsVersion)
      ())
    ("tools/common/skill" "SICO_batchAdapter.il" "ac1764cffc06b1259bcf761b69a56d9e64540cc114d7faafd96950f612e5705b"
      (cadBatchFlowKey cadBatchRegisterFlowAdapter cadBatchFlowAdapter cadBatchAdapterCallback
       cadBatchAdapterCall cadBatchFlowPairedP cadBatchAdapterEnterMultiple cadBatchAdapterLeaveMultiple
       cadBatchAdapterOpenResult cadBatchAdapterPythonExe cadBatchAdapterRevision)
      ((cadBatchAdapterRevision "20260812.common.v1"))
      (cadBatchAdapterVersion)
      ())
    ("tools/common/skill" "SICO_batchGui.il" "2936bed6bb24bd743d33cf4a1bce935dd75ff56fcaba49c631bf9272e04ab1f4"
      (cadBatchPairedFlowP cadBatchMessage cadBatchCreateLcvEditor cadBatchCreateSyncButtons
       cadBatchCreateTaskReport cadBatchCreateTaskContextMenu cadBatchCreateTaskButtons
       cadBatchCreateTaskLayout cadBatchMultipleP cadBatchScopeCB cadBatchBindForm
       cadBatchGuiSharedRevision)
      ((cadBatchGuiSharedRevision "20260812.common.v1"))
      (cadBatchGuiVersion)
      ())
    ("tools/common/skill" "SICO_batchRows.il" "83b4c64e1dc5179c541f37d47c1ab5d04dabb577cc8836869e5cb2e5d51c2035"
      (cadBatchFieldValue cadBatchCopyLcvCB cadBatchEditorValues cadBatchSetEditorValues
       cadBatchSetDesignValues cadBatchDesignValues cadBatchRowValidP cadBatchRowKey
       cadBatchDuplicateRowP cadBatchReplaceAt cadBatchRemoveAt cadBatchIndexValidP cadBatchRefreshReport
       cadBatchSelectedIndex cadBatchTaskReportCB cadBatchTaskDoubleClickCB cadBatchTaskContextMenuCB
       cadBatchDeleteSelectedMappingCB cadBatchAddUpdateCB cadBatchRemoveCB cadBatchClearCB
       cadBatchValidateTasks cadBatchRowsRevision)
      ((cadBatchRowsRevision "20260812.common.v1"))
      (cadBatchRowsVersion)
      ())
    ("tools/common/skill" "SICO_batchCore.il" "70f3575326a75d3463a6620ba5de2f1046fba29ca17f40ea2d2b89a4299dbc0b"
      (cadBatchDispatchStart cadBatchSafeToken cadBatchNewId cadBatchCreateRoot cadBatchMakeSpec
       cadBatchSpecSet cadBatchTaskId cadBatchJobName cadBatchPythonExe cadBatchPythonEntry
       cadBatchControllerCommand cadBatchWriteManifest cadBatchBuildMeta cadBatchSpecById
       cadBatchSpecsIndependentP cadBatchLaunch cadBatchCancel cadBatchIpcDataHandler
       cadBatchIpcErrHandler cadBatchIpcPostFunc cadBatchCoreRevision)
      ((cadBatchCoreRevision "20261020.batch.commands.v4"))
      (sicoBatchCoreVersion)
      ())
    ("tools/common/skill" "SICO_batchMonitor.il" "84c5583d6294ebbb07c6cc489f319ffdeeb14f82e627214fae7f8012b2476add"
      (cadBatchMonitorFormValidP cadBatchMonitorDropStaleForm cadBatchMonitorReadRows
       cadBatchMonitorInitialRows cadBatchMonitorChoices cadBatchMonitorSummary
       cadBatchMonitorSelectedRow cadBatchMonitorSelectedSpec cadBatchMonitorOpenResultCB
       cadBatchMonitorOpenLogCB cadBatchMonitorCancelCB cadBatchMonitorRefreshCB cadBatchMonitorRefresh
       cadBatchMonitorTimer cadBatchMonitorDisplay cadBatchMonitorRevision cadBatchMonitorAuditRevision)
      ((cadBatchMonitorRevision "20260902.form.lifecycle.v1") (cadBatchMonitorAuditRevision
       "20260911.flow.audit.v1"))
      (sicoBatchMonitorAuditVersion)
      ())
    ("tools/common/skill++" "BATCHGUI.ils" "03469891ea04c332e533749c19e386d297f3a65d4f6c17700a7f79074b1438ef"
      (makeBatchControls makeBatchParallelCells cadBatchGuiRevision)
      ((cadBatchGuiRevision "20260812.common.v1"))
      ()
      (BATCHGUI))
    ("tools/common/skill++" "PROFILEGUI.ils" "52ca0cd1b7a1e7ecb7967b59727bfe6f025b4edbdcf5008f20d702436479a26d"
      (makeProfileControls SICO_profileGuiRevision)
      ((SICO_profileGuiRevision "20260818.profile.gui.v2"))
      ()
      (PROFILEGUI))
    ("tools/utility/skill" "UI_messageApp.il" "c18059abe7eea9a1732e5191f5152e790c89a16c95af353407c6cfa32698fe0d"
      (GUI_messageApp)
      ()
      (sicoGuiMessageAppVersion)
      ())
    ("tools/utility/skill" "UI_askApp.il" "da2f0fadc7134c1080c1928444d3a694fff27621be6f0dfc29ad68bf5e03c814"
      (GUI_askApp)
      ()
      (sicoGuiAskAppVersion)
      ())
    ("tools/utility/skill" "UI_windowIcon.il" "aa994884e43c073f2106d8764b0c5535453bf359a62623a17fdbe15b0204345f"
      (SICO_windowIconRevision SICO_windowIconBrand SICO_windowIconPath SICO_windowIcon
       SICO_setWindowIcon)
      ((SICO_windowIconRevision "20260921.sico.flow.icon.v1"))
      (sicoWindowIconVersion)
      ())
    ("tools/utility/skill" "UI_flowLog.il" "fa1227aac8aafcba39e675306b8ba22ec34140fbf9939b1687c3422650bcc65c"
      (GUI_flowLogBrand GUI_flowLogWindowClosed GUI_flowLogCreate GUI_flowLogOpenRequest GUI_flowLogOpen
       GUI_flowLogShow GUI_flowLogClose GUI_flowLogRevision)
      ((GUI_flowLogRevision "20260721.flow.log.owned.v2"))
      (sicoFlowLogVersion)
      ())
  ))
)
