unless(and(isCallable('SICO_lsfLocalHost)
             isCallable('SICO_lsfAutoHost))
  cond(
    (and(boundp('lvsCommonRoot) lvsCommonRoot)
      load(strcat(lvsCommonRoot "/skill/SICO_lsf.il")))
    (isCallable('cadLoadRelative)
      cadLoadRelative("common/skill/SICO_lsf.il"))
    (t
      warn("STAGECFG requires the shared CAD LSF helper.\n"))
  )
)

defstruct(lvsstagestr
title cmd formdone outDirChoices outDirCB defOutDir lsfChoicesCB queueCB
runTypeChoices defQueueName queueChoices defSrvName srvChoices
cpuChoices
)

procedure(lvsStageProjectDir(stage)
  SICO_envValue(
    if(stage=="gds" then "GDS_DB_DIR" else "CDL_DB_DIR"))
)

procedure(lvsStageInitializeConfig()
  streamGdsStruc=make_lvsstagestr(
  ?title          strcat(SICO_logo() "::Stream GDS")
  ?cmd            'streamGdsRunCB
  ?formdone       'streamGdsFormDoneCB
  ?outDirChoices  '("Project Directory" "Current Directory" "Customize Directory")
  ?outDirCB       "lvsStageOutDirCB(hiGetCurrentForm() \"gds\")"
  ?defOutDir      or(lvsStageProjectDir("gds") getWorkingDir())
  ?lsfChoicesCB   "lvsStageLsfChoicesCB(hiGetCurrentForm())"
  ?queueCB        "SICO_lsfQueueChoicesCB(hiGetCurrentForm())"
  ?runTypeChoices '("Current Host" "LSF Farm")
  ?defQueueName   ""
  ?queueChoices   list("")
  ?defSrvName     SICO_lsfLocalHost()
  ?srvChoices     list(SICO_lsfLocalHost())
  ?cpuChoices     or(parseString(or(SICO_envValue("SICO_FLOW_CPU_ALLOW") "") ", \t")
                     '("1" "2" "4" "8"))
  )

  exportCdlStruc=make_lvsstagestr(
  ?title          strcat(SICO_logo() "::Export CDL")
  ?cmd            'exportCdlRunCB
  ?formdone       'exportCdlFormDoneCB
  ?outDirChoices  '("Project Directory" "Current Directory" "Customize Directory")
  ?outDirCB       "lvsStageOutDirCB(hiGetCurrentForm() \"cdl\")"
  ?defOutDir      or(lvsStageProjectDir("cdl") getWorkingDir())
  ?lsfChoicesCB   "lvsStageLsfChoicesCB(hiGetCurrentForm())"
  ?queueCB        "SICO_lsfQueueChoicesCB(hiGetCurrentForm())"
  ?runTypeChoices '("Current Host" "LSF Farm")
  ?defQueueName   ""
  ?queueChoices   list("")
  ?defSrvName     SICO_lsfLocalHost()
  ?srvChoices     list(SICO_lsfLocalHost())
  ?cpuChoices     or(parseString(or(SICO_envValue("SICO_FLOW_CPU_ALLOW") "") ", \t")
                     '("1" "2" "4" "8"))
  )

  lvsStageMsgStruc=make_lvsstagemsg(
    ?projShellNotSet "The flow-specific project directory was not set; using current directory."
    ?dirExist        "Run directory doesn't exist. Creating..."
    ?dirAccess       "Cannot create run directory. Check path and permissions."
    ?inputOaSch      "Schematic library/cell/view was not specified."
    ?inputOaLay      "Layout library/cell/view was not specified."
    ?cdlIncludeFile  "CDL include file was not specified or cannot be accessed."
    ?noConfig        "Cannot create stage TOML."
  )
  t
)

defstruct(lvsstagemsg
projShellNotSet dirExist dirAccess inputOaSch inputOaLay cdlIncludeFile noConfig
)

unless(getShellEnvVar("VIRTUOSO_CONTEXT_BUILD")=="1"
  lvsStageInitializeConfig()
)

procedure(lvsStageCdlIncludeConfigRevision()
  "20260812.cdl.include.v2"
)
