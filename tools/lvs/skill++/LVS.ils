; Generated by tools/utility/skill_loader.py --write; edit the manifest/sources.
; Source-only. Per-file contracts retain successful members across retries.
let((entryDirectory)
  entryDirectory=strcat("/" buildString(reverse(cdr(reverse(
    parseString(simplifyFilename(get_filename(piport) t) "/")))) "/"))
  load(strcat(entryDirectory "/../../../scripts/sicoSkillLoader.ils"))
  load(strcat(entryDirectory "/../../../scripts/skill/flow.ils"))
  lvsToolsRoot=strcat(SICO_sourceRoot() "/tools")
  lvsSkillRoot=strcat(SICO_sourceRoot() "/tools/lvs")
  lvsCommonRoot=strcat(SICO_sourceRoot() "/tools/common")
  lvsUtilityRoot=strcat(SICO_sourceRoot() "/tools/utility")
  SICO_sourceRequire("lvs" "3009d92d06d4d20b9a7e8c74b1ffaf140e3de9ef90b4333dd263841496d97995" '(
    ("tools/lvs/skill++" "LVSCFG.ils" "fc8f5dab1c7928f9e855216e80d11eed8844e2ec05b12e33618ad2c26bbaf63e"
      (lvsInitializeConfig lvsCdlIncludeConfigRevision)
      ((lvsCdlIncludeConfigRevision "20260812.cdl.include.v2"))
      ()
      ())
    ("tools/lvs/skill++" "STAGECFG.ils" "33eabf276063683f4e7c9f517980a8e6dae65fb0b6c800920b6e47e8f9cf498a"
      (lvsStageProjectDir lvsStageInitializeConfig lvsStageCdlIncludeConfigRevision)
      ((lvsStageCdlIncludeConfigRevision "20260812.cdl.include.v2"))
      ()
      ())
    ("tools/lvs/skill++" "LVSCB.ils" "a9423bf2ab127de53b41f9b516419135ce2ea3946d4645652543a45411d91104"
      (lvsFrontendRevision lvsFormValidP lvsFormDoneCB lvsRunCB lvsRunCloseCB lvsReportCB
       lvsCustomSvrfRevision lvsCdlIncludeRevision lvsAbsolutePathRevision lvsInputSyncRevision
       lvsRunModeCB lvsInpCB lvsSyncInputNames lvsCdlFileCB lvsGdsFileCB lvsOutDirCB lvsRunsetCB
       lvsHcellCB lvsVirtualConnCB lvsLsfChoicesCB lvsRunDirFromForm lvsWriteToml)
      ((lvsFrontendRevision "20260924.flow.environment.v3") (lvsCustomSvrfRevision
       "20260813.custom.svrf.common.v1") (lvsCdlIncludeRevision "20260812.cdl.include.v2")
       (lvsAbsolutePathRevision "20260812.toml.absolute.paths.v1") (lvsInputSyncRevision
       "20260817.input.sync.v1"))
      ()
      ())
    ("tools/lvs/skill++" "LVSRUN.ils" "b25dc15464aac108ed66b355c1bd6ee9bc32e1b852c746496cf5aba1544e6294"
      (LVS_pythonEntry lvsRunUsesCadTempPath lvsLogDirRevision lvsRveLauncherRevision lvsRunDirFromConfig
       LVS_pythonExe LVS_launchEnvCommand lvsTopCellFromForm lvsSvdbDirFromForm lvsBackupRunData
       lvsIpcDataHandler lvsIpcErrHandler lvsLogContainsCorrect lvsCompletionCorrectP
       lvsShowCompletionSummary lvsIpcPostFunc lvsStart lvsBatchSpec lvsBatchStart lvsOpenRve
       lvsPromptOpenRve lvsReport lvsBatchEnterMultiple lvsCdlIncludeBatchRevision lvsBatchLeaveMultiple
       lvsBatchOpenResult)
      ((lvsLogDirRevision "20260817.log.artifacts.v1") (lvsRveLauncherRevision
       "20260828.prompt.return.v1") (lvsCdlIncludeBatchRevision "20260812.cdl.include.v2"))
      ()
      ())
    ("tools/lvs/skill++" "STAGECB.ils" "892f8143ec94150a4765f23d230a310ebd42d76846d44711b5b5572ba8a8e523"
      (lvsStageOutDirCB lvsStageFormValidP streamGdsFormDoneCB streamGdsRunCB streamGdsRunCloseCB
       exportCdlFormDoneCB exportCdlRunCB exportCdlRunCloseCB lvsStageLsfChoicesCB lvsStageLabel
       lvsStageCommandName lvsStagePrefix lvsStageTomlName lvsStageRunDirFromForm lvsStageOutputName
       lvsStageValidateForm lvsStageWriteToml lvsStageCdlIncludeRevision lvsStageAbsolutePathRevision
       lvsStageUsesCadTempPath lvsStageRunRootRevision lvsStageBackupRunData lvsStageIpcDataHandler
       lvsStageIpcErrHandler lvsStageIpcPostFunc lvsStageStart)
      ((lvsStageCdlIncludeRevision "20260812.cdl.include.v2") (lvsStageAbsolutePathRevision
       "20260812.toml.absolute.paths.v1") (lvsStageRunRootRevision "20260924.flow.environment.v3"))
      ()
      ())
    ("tools/lvs/skill++" "LVSPROFILE.ils" "fd96e9fa4a9a64f2bfe001890d143a7649d1c01a832cf2833a981be1160247ab"
      (lvsSvdbQueryFromForm lvsSvdbQueryFlags lvsProfileCollect lvsProfileApply lvsProfileRevision)
      ((lvsProfileRevision "20260820.rce.live.log.v4"))
      ()
      ())
    ("tools/lvs/skill++" "LVSGUI.ils" "5a481079baab85e73bd4e94317e7c19c7e673a43e97026a3ec2333c58d56f7f3"
      (makeLvsCpus makeLvsSvdbQuery makeLvsInputNameSync makeInpLay makeOutLay makeLvsOptLay
       makeLvsRunMode makeHardwareLay makeToolLay makeMainLay makeForm cadDisplayLvsForm
       lvsCustomSvrfGuiRevision lvsCdlIncludeGuiRevision lvsInputSyncGuiRevision
       lvsAdvancedOptionsGuiRevision)
      ((lvsCustomSvrfGuiRevision "20260813.custom.svrf.common.v1") (lvsCdlIncludeGuiRevision
       "20260812.cdl.include.layout.v3") (lvsInputSyncGuiRevision "20260817.input.sync.v1")
       (lvsAdvancedOptionsGuiRevision "20260817.advanced.options.v1"))
      ()
      (LVSGUI))
    ("tools/lvs/skill++" "STAGEGUI.ils" "68b88f13a115ad9d4815ffefe6ec95bd9c7d5246509d79fafbb19f5ed2d6557f"
      (makeStageOptions makeInpLay makeOutLay makeHardwareLay makeMainLay makeForm
       cadDisplayStreamGdsForm cadDisplayExportCdlForm lvsStageCdlIncludeGuiRevision)
      ((lvsStageCdlIncludeGuiRevision "20260812.cdl.include.v2"))
      ()
      (STAGEOPTIONSGUI STREAMGDSGUI EXPORTCDLGUI))
  ))
)
