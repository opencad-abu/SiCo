unless(isCallable('SICO_envPairNames)
  cond(
    (and(boundp('lvsCommonRoot) lvsCommonRoot)
      load(strcat(lvsCommonRoot "/skill/SICO_envOptions.il")))
    (isCallable('cadLoadRelative)
      cadLoadRelative("common/skill/SICO_envOptions.il"))
    (t
      warn("LVSCFG requires LVS.ils or a configured SICO_HOME.\n"))
  )
)

unless(and(isCallable('SICO_lsfLocalHost)
             isCallable('SICO_lsfAutoHost))
  cond(
    (and(boundp('lvsCommonRoot) lvsCommonRoot)
      load(strcat(lvsCommonRoot "/skill/SICO_lsf.il")))
    (isCallable('cadLoadRelative)
      cadLoadRelative("common/skill/SICO_lsf.il"))
    (t
      warn("LVSCFG requires the shared CAD LSF helper.\n"))
  )
)

defstruct(lvsstr
title cmd reportCmd formdone inpChoices inpCB cdlFileCB gdsFileCB outDirChoices
outDirCB defOutDir lvsHcellCB lvsVirtualConnCB lsfChoicesCB queueCB runTypeChoices
defQueueName queueChoices defSrvName srvChoices cpuChoices lvsToolChoices lvsToolDefValue
lvsRunsetEnvName lvsRunsetChoices lvsRunsetCB
)

procedure(lvsInitializeConfig()
  lvsStruc=make_lvsstr(
  ?title                strcat(SICO_logo() "::LVS")
  ?cmd                  'lvsRunCB
  ?reportCmd            'lvsReportCB
  ?formdone             'lvsFormDoneCB
  ?inpChoices           '("OA" "CDL+GDS" "CDL+LAY" "SCH+GDS")
  ?inpCB                '("lvsInpCB(hiGetCurrentForm())")
  ?cdlFileCB            "lvsCdlFileCB(hiGetCurrentForm())"
  ?gdsFileCB            "lvsGdsFileCB(hiGetCurrentForm())"
  ?outDirChoices        '("Project Directory" "Current Directory" "Customize Directory")
  ?outDirCB             "lvsOutDirCB(hiGetCurrentForm())"
  ?defOutDir            or(SICO_envValue("LVS_DB_DIR") pwd())
  ?lvsRunsetEnvName     "LVS_FILE"
  ?lvsRunsetChoices     SICO_envPairNames("LVS_FILE")
  ?lvsRunsetCB          "lvsRunsetCB(hiGetCurrentForm())"
  ?lvsHcellCB           "lvsHcellCB(hiGetCurrentForm())"
  ?lvsVirtualConnCB     '("lvsVirtualConnCB(hiGetCurrentForm())")
  ?lsfChoicesCB         "lvsLsfChoicesCB(hiGetCurrentForm())"
  ?queueCB              "SICO_lsfQueueChoicesCB(hiGetCurrentForm())"
  ?runTypeChoices       '("Current Host" "LSF Farm")
  ?defQueueName         ""
  ?queueChoices         list("")
  ?defSrvName           SICO_lsfLocalHost()
  ?srvChoices           list(SICO_lsfLocalHost())
  ?cpuChoices           or(parseString(or(SICO_envValue("SICO_FLOW_CPU_ALLOW") "") ", \t")
                           '("1" "2" "4" "8"))
  ?lvsToolChoices       '("Calibre")
  ?lvsToolDefValue      or(getShellEnvVar("LVS_DEF_TOOL") "Calibre")
  )

  lvsMsgStruc=make_lvsmsg(
    ?projShellNotSet "LVS_DB_DIR was not set; using current directory."
    ?dirExist        "Run directory doesn't exist. Creating..."
    ?dirAccess       "Cannot create run directory. Check path and permissions."
    ?inputOaSch      "Schematic library/cell/view was not specified."
    ?inputOaLay      "Layout library/cell/view was not specified."
    ?gdsFile         "GDS file was not specified or cannot be accessed."
    ?gdsCell         "GDS cell name was not specified."
    ?cdlFile         "CDL file was not specified or cannot be accessed."
    ?cdlCell         "CDL cell name was not specified."
    ?hcellFile       "Hcell file was not specified or cannot be accessed."
    ?cdlIncludeFile  "CDL include file was not specified or cannot be accessed."
    ?noConfig        "Cannot find lvs.toml. Run LVS first."
    ?noSvdb          "Cannot find SVDB directory. Run LVS first."
  )
  t
)

defstruct(lvsmsg
projShellNotSet dirExist dirAccess inputOaSch inputOaLay
gdsFile gdsCell cdlFile cdlCell hcellFile cdlIncludeFile noConfig noSvdb
)

unless(getShellEnvVar("VIRTUOSO_CONTEXT_BUILD")=="1"
  lvsInitializeConfig()
)

procedure(lvsCdlIncludeConfigRevision()
  "20260812.cdl.include.v2"
)
