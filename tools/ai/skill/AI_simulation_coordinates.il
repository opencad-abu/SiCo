; Verify actual history parameters, never infer tuple order from ADE point IDs.
procedure(aiSimCoordinateParam(asvCorner asvName)
  prog((asvValues)
    asvValues=setof(asvParam asvCorner->params() asvParam->name==asvName)
    unless(length(asvValues)==1 error("missing/duplicate coordinate parameter: %s" asvName))
    return(car(asvValues)->value)))
procedure(aiSimCoordinateNumber(asvActual asvExpected)
  and(numberp(asvActual) abs(asvActual-asvExpected)<=max(abs(asvExpected)*1e-12 1e-30)))
procedure(aiSimVerifyCoordinates(asvRun asvDb)
  prog((asvPayload asvSeen asvValues asvKey asvCornerRow asvModels asvActual asvMatches asvRows asvPointTuples asvModelParams)
    asvPayload=aiSimulationSetups[asvRun['setup]]['payload]
    unless(length(asvDb->points())==aiSimDimensionCount(asvPayload) error("actual sweep point count differs"))
    foreach(asvPoint asvDb->points()
      asvPointTuples=nil
      foreach(asvCorner asvPoint->corners()
        asvCornerRow=assoc(asvCorner->name nth(4 asvPayload))
        if(nth(4 asvPayload) then
          unless(asvCornerRow error("unexpected RDB corner"))
          unless(aiSimCoordinateNumber(aiSimCoordinateParam(asvCorner "temperature") atof(cadr(asvCornerRow)))
            error("actual corner temperature differs"))
          foreach(asvVar caddr(asvCornerRow)
            unless(aiSimCoordinateNumber(aiSimCoordinateParam(asvCorner car(asvVar)) atof(cadr(asvVar)))
              error("actual corner variable differs")))
          asvModelParams=setof(asvP asvCorner->params() asvP->name=="corModelSpec")
          ; RDB uses (path nil) for a sectionless model; payload may use (path).
          asvModels=foreach(mapcar asvModel nth(3 asvCornerRow) list(car(asvModel) cadr(asvModel)))
          unless(or(and(!asvModels !asvModelParams) length(asvModelParams)==1)
            error("missing/duplicate corner model coordinate"))
          asvActual=when(asvModelParams car(asvModelParams)->value)
          unless(equal(asvActual asvModels) error("actual corner models differ: %L vs %L" asvActual asvModels))
        else unless(asvCorner->name=="nominal" error("unexpected nominal corner name")))
        asvValues=nil
        foreach(asvSweep nth(5 asvPayload)
          asvActual=aiSimCoordinateParam(asvCorner car(asvSweep))
          asvMatches=setof(asvValue caddr(asvSweep) aiSimCoordinateNumber(asvActual asvValue))
          unless(length(asvMatches)==1 error("unexpected actual sweep value"))
          asvValues=cons(list(car(asvSweep) car(asvMatches)) asvValues))
        asvValues=reverse(asvValues)
        when(asvPointTuples unless(equal(asvPointTuples asvValues) error("sweep tuple differs between corners")))
        asvPointTuples=asvValues asvKey=list(asvCorner->name asvValues)
        when(member(asvKey asvSeen) error("duplicate actual corner/sweep tuple")) asvSeen=cons(asvKey asvSeen)
        asvRows=cons(list(asvPoint->id asvCorner->name asvValues
          when(asvCornerRow atof(cadr(asvCornerRow))) when(asvCornerRow nth(3 asvCornerRow))) asvRows)))
    unless(length(asvSeen)==aiSimDimensionCount(asvPayload)*max(1 length(nth(4 asvPayload)))
      error("corner/sweep tuple coverage incomplete"))
    asvRun['coordinates]=reverse(asvRows) return(t)))
