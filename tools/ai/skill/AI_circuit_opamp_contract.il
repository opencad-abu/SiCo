; Qualified reference semantics used by the measurement units and expected matrix.
procedure(aiOpampReferenceContract(aocSession)
  prog((aocTs aocMatches aocModel)
    unless(and(equal(maeGetSetup(?typeName "tests" ?session aocSession) list("AC" "TRAN"))
      equal(maeGetSetup(?typeName "tests" ?enabled t ?session aocSession) list("AC" "TRAN"))
      equal(maeGetSetup(?typeName "corners" ?enabled t ?session aocSession) list("Nominal")))
      error("reference tests/corner matrix differs"))
    foreach(aocVar list(list("rload" "1K") list("cload" "100f") list("vdd" "1.3") list("nomGain" "0"))
      unless(maeGetVar(car(aocVar) ?session aocSession)==cadr(aocVar) error("reference variable differs")))
    foreach(aocTest list("AC" "TRAN")
      aocTs=maeGetTestSession(aocTest ?session aocSession)
      unless(and(asiGetDesignLibName(aocTs)=="Two_Stage_Opamp"
        asiGetDesignCellName(aocTs)==strcat("OpAmp_" aocTest "_top")
        asiGetDesignViewName(aocTs)=="schematic" asiGetSimName(aocTs)=="spectre") error("reference test design differs"))
      aocModel=assoc("modelFiles" maeGetEnvOption(aocTest ?session aocSession))
      unless(and(aocModel length(cadr(aocModel))==1 cadar(cadr(aocModel))=="mc") error("reference model section differs")))
    foreach(aocRow list(
      list("AC" "Current" "abs(IDC(\"/V1/PLUS\"))")
      list("AC" "UGF" "cross(dB20(mag(VF(\"/OUT\"))) 0 1 \"falling\")")
      list("AC" "Gain" "value(dB20(mag(VF(\"/OUT\"))) 1)")
      list("AC" "Voffset" "(VDC(\"/inm\") - VDC(\"/inp\"))")
      list("AC" "nomGain" "VAR(\"nomGain\")")
      list("TRAN" "Swing" "(value(VT(\"/OUT\") 2.5e-08) - value(VT(\"/OUT\") 1e-09))")
      list("TRAN" "SettlingTime" "settlingTime(VT(\"/OUT\") 0 t 2.5e-08 t 10 nil \"time\")")
      list("TRAN" "RelativeSwingPercent" "((Swing / VAR(\"vdd\")) * 100)")
      list("TRAN" "PhaseMargin" "getData(\"/phaseMargin\" ?result \"stb_margin\")"))
      aocMatches=setof(aocOut maeGetTestOutputs(car(aocRow) ?session aocSession) aocOut->name==cadr(aocRow))
      unless(and(length(aocMatches)==1 sprintf(nil "%L" car(aocMatches)->expression)==caddr(aocRow))
        error("reference measurement expression differs: %s" cadr(aocRow))))
    return(t)))
