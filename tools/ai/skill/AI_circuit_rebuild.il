; Task-bound new DUT/symbol/AC/TRAN views. Failure preserves partial targets.
procedure(aiRebuildReply(abrEntry)
  aiCircuitObject(list(list("ok" aiCircuitBool(!abrEntry['error])) list("circuit_ref" abrEntry['ref])
    list("targets" foreach(mapcar abrV abrEntry['views] car(abrV))) list("stage" abrEntry['stage])
    list("saved" aiCircuitBool(abrEntry['saved])) list("checks" abrEntry['checks])
    list("presentation" abrEntry['mode]) list("interface_check" abrEntry['interface])
    list("reference_dependency" list("Two_Stage_Opamp" "opamp_dc_feedback" "schematic"))
    list("simulation_qualified" 'jsonFalse) list("error" abrEntry['error]))))
procedure(aiRebuildPreview(abpTask abpRequest abpLib abpCell abpRoot abpSource)
  prog((abpRecord abpResult abpEntry)
    unless(aiCircuitTasks[abpTask] return(aiCircuitError("task_not_found" "Confirmed task required")))
    abpResult=errset(aiRcReserve(strcat("rebuild-preview:" abpRequest) list(abpTask abpLib abpCell abpRoot abpSource)) nil)
    unless(abpResult return(aiCircuitError("request_conflict_or_limit" "Preview request conflict/limit")))
    abpRecord=car(abpResult) when(abpRecord['reply] return(abpRecord['reply]))
    abpResult=errset(progn(
      unless(and(ddGetObj(abpLib) ddIsObjWritable(ddGetObj(abpLib))
        !member(abpLib list("gpdk045" "Two_Stage_Opamp" "analogLib" "basic"))) error("separate writable work library required"))
      unless(and(simplifyFilename(ddGetObj("gpdk045")~>readPath)==simplifyFilename(strcat(abpRoot "/gpdk045"))
        simplifyFilename(ddGetObj("Two_Stage_Opamp")~>readPath)==simplifyFilename(abpSource)) error("reference paths differ"))
      abpEntry=makeTable("aiRebuildPreview" nil) abpEntry['ref]=strcat("rebuild-preview:" abpRequest)
      abpEntry['task]=abpTask abpEntry['lib]=abpLib abpEntry['cell]=abpCell abpEntry['root]=abpRoot
      abpEntry['workPath]=simplifyFilename(ddGetObj(abpLib)~>readPath)
      abpEntry['sourcePath]=simplifyFilename(abpSource)
      aiRebuildPaths(abpEntry)
      abpEntry['sources]=aiRebuildSources()
      aiRebuildSourceContract(abpEntry['sources])
      abpEntry['masters]=aiRebuildMasters(abpEntry['sources])
      unless(equal(foreach(mapcar abpS abpEntry['sources] length(cadr(abpS))) list(12 12 9 14)) error("reference device counts differ"))
      aiRebuildPreviews[abpEntry['ref]]=abpEntry
      abpRecord['reply]=aiCircuitObject(list(list("ok" t) list("preview_ref" abpEntry['ref])
        list("target" list(abpLib abpCell)) list("presentation" aiCircuitTasks[abpTask])
        list("source_device_counts" foreach(mapcar abpS abpEntry['sources] list(car(abpS) length(cadr(abpS)))))
        list("ports" caddr(car(abpEntry['sources]))) list("parameter_policy" "preserve_reference_effective_and_stored_values")
        list("layout_policy" "DUT source placement, input pins lower-left, labelled TB groups")
        list("simulation_qualified" 'jsonFalse))) t) t)
    unless(abpResult return(aiCircuitError("preview_failed" "Reference capture failed; inspect CIW")))
    return(abpRecord['reply])))
procedure(aiRebuildCheck(abcCv abcSource abcMap abcEntry)
  prog((abcInst abcExpectedLib abcExpectedCell)
    unless(length(abcCv~>instances)==length(cadr(abcSource))+length(caddr(abcSource)) error("instance count differs"))
    foreach(abcRow cadr(abcSource)
      abcInst=dbFindAnyInstByName(abcCv cadr(assoc(car(abcRow) abcMap)))
      abcExpectedLib=cadr(abcRow) abcExpectedCell=caddr(abcRow)
      when(and(abcExpectedLib=="Two_Stage_Opamp" abcExpectedCell=="OpAmp")
        abcExpectedLib=abcEntry['lib] abcExpectedCell=abcEntry['cell])
      unless(and(abcInst abcInst~>libName==abcExpectedLib abcInst~>cellName==abcExpectedCell
        equal(aiRebuildConnections(abcInst) nth(7 abcRow)) equal(aiGateParams(abcInst) nth(6 abcRow)))
        error("master/connectivity/CDF differs: %s" car(abcRow))))
    unless(equal(sort(foreach(mapcar abcT abcCv~>terminals list(abcT~>name abcT~>direction abcT~>net~>name))
      'aiConfigRowLess) caddr(abcSource)) error("ports differ"))
    return(t)))
procedure(aiRebuildBuild(abbEntry abbCell abbView abbSource)
  prog((abbCv abbWindow abbMap abbCheck abbResult abbTarget)
    abbTarget=list(abbEntry['lib] abbCell abbView) abbEntry['stage]=strcat(abbCell "/" abbView)
    unwindProtect(progn(
      if(abbEntry['mode]=="foreground" then
        abbWindow=deNewCellView(abbEntry['lib] abbCell abbView if(abbView=="symbol" "schematicSymbol" "schematic") nil)
        unless(abbWindow error("new window failed"))
        aiCircuitRaiseWindow(abbWindow)
        abbCv=dbOpenCellViewByType(abbEntry['lib] abbCell abbView "" "r")
      else abbCv=dbOpenCellViewByType(abbEntry['lib] abbCell abbView if(abbView=="symbol" "schematicSymbol" "schematic") "a"))
      unless(abbCv error("new view failed"))
      cond((abbView=="symbol"
          aiRebuildSymbol(abbCv caddr(abbSource)) abbCheck="ports_verified")
        (car(abbSource)=="OpAmp"
          abbCheck=aiRebuildDut(abbCv abbSource)
          abbMap=foreach(mapcar abbI cadr(abbSource) list(car(abbI) car(abbI))))
        (t abbResult=aiRebuildTb(abbCv abbSource abbEntry['lib] abbEntry['cell]) abbCheck=car(abbResult) abbMap=cadr(abbResult)))
      when(abbView=="schematic"
        unless(equal(abbCheck list(0 0)) error("check failed: %L" abbCheck))
        aiRebuildCheck(abbCv abbSource abbMap abbEntry))
      unless(dbSave(abbCv) error("save failed"))
      abbEntry['views]=append(abbEntry['views] list(list(abbTarget aiGateSnapshot(abbCv) abbSource abbWindow abbMap)))
      abbEntry['checks]=append(abbEntry['checks] list(list(abbTarget abbCheck)))
      when(abbWindow hiZoomIn(abbWindow list(
        list(xCoord(car(abbCv~>bBox))-0.5 yCoord(car(abbCv~>bBox))-0.5)
        list(xCoord(cadr(abbCv~>bBox))+0.5 yCoord(cadr(abbCv~>bBox))+0.5)))) t)
      when(abbCv dbClose(abbCv)))
    return(t)))
procedure(aiRebuildValidate(abvEntry)
  let((abvCv abvTarget abvWindow)
    unless(abvEntry error("unknown rebuild"))
    unless(aiCircuitTasks[abvEntry['task]]==abvEntry['mode] error("task mode changed"))
    aiRebuildPaths(abvEntry)
    unless(equal(aiRebuildMasters(abvEntry['sources]) abvEntry['masters]) error("reference master changed"))
    unless(equal(aiRebuildSources() abvEntry['sources]) error("reference changed"))
    foreach(abvV abvEntry['views]
      abvTarget=car(abvV) abvWindow=nth(3 abvV)
      when(abvEntry['mode]=="foreground"
        unless(and(member(abvWindow hiGetWindowList('all)) aiCircuitCvMatches(geGetWindowCellView(abvWindow) abvTarget)
          geGetWindowCellView(abvWindow)==geGetEditCellView(abvWindow)) error("window closed/rebound/EIP")))
      abvCv=nil
      unwindProtect(progn(
        abvCv=dbOpenCellViewByType(car(abvTarget) cadr(abvTarget) caddr(abvTarget) "" "r")
        unless(and(abvCv !dbIsCellViewModified(abvCv) equal(aiGateSnapshot(abvCv) cadr(abvV))) error("view modified"))
        when(caddr(abvTarget)=="schematic" aiRebuildCheck(abvCv nth(2 abvV) nth(4 abvV) abvEntry)))
        when(abvCv dbClose(abvCv)))) t))
procedure(aiRebuildCreate(abcPreview abcRequest abcRoot)
  prog((abcP abcRecord abcEntry abcResult abcRead)
    abcP=aiRebuildPreviews[abcPreview]
    unless(and(abcP abcP['root]==abcRoot) return(aiCircuitError("preview_not_found" "Preview missing or model root differs")))
    abcResult=errset(aiRcReserve(strcat("rebuild:" abcRequest) list(abcPreview abcRoot)) nil)
    unless(abcResult return(aiCircuitError("request_conflict_or_limit" "Rebuild request conflict/limit")))
    abcRecord=car(abcResult) when(abcRecord['entry] return(aiRebuildReply(abcRecord['entry])))
    abcEntry=makeTable("aiRebuildEntry" nil)
    foreach(abcKey list('task 'lib 'cell 'root 'sources 'workPath 'sourcePath 'masters) abcEntry[abcKey]=abcP[abcKey])
    abcEntry['ref]=strcat("rebuild:" abcRequest) abcEntry['mode]=aiCircuitTasks[abcP['task]]
    abcEntry['stage]="preflight" abcRecord['entry]=abcEntry aiRebuildEntries[abcEntry['ref]]=abcEntry
    abcResult=errset(progn(
      aiRebuildPaths(abcEntry)
      unless(member(abcEntry['mode] list("foreground" "background")) error("task lost"))
      when(and(abcEntry['mode]=="foreground" !aiCircuitGuiP()) error("GUI unavailable"))
      unless(equal(aiRebuildMasters(abcEntry['sources]) abcEntry['masters]) error("reference master changed"))
      foreach(abcSuffix list("" "_ac_tb" "_tran_tb")
        when(ddGetObj(abcEntry['lib] strcat(abcEntry['cell] abcSuffix)) error("target exists")))
      unless(equal(aiRebuildSources() abcEntry['sources]) error("source changed since preview"))
      aiRebuildBuild(abcEntry abcEntry['cell] "schematic" car(abcEntry['sources]))
      aiRebuildBuild(abcEntry abcEntry['cell] "symbol" car(abcEntry['sources]))
      aiRebuildBuild(abcEntry strcat(abcEntry['cell] "_ac_tb") "schematic" cadr(abcEntry['sources]))
      aiRebuildBuild(abcEntry strcat(abcEntry['cell] "_tran_tb") "schematic" caddr(abcEntry['sources]))
      abcEntry['stage]="saved_readback"
      aiRebuildValidate(abcEntry)
      unwindProtect(progn(
        abcRead=dbOpenCellViewByType(abcEntry['lib] abcEntry['cell] "schematic" "" "r")
        abcEntry['interface]=schVIC(abcRead)
        unless(equal(abcEntry['interface] list(0 0)) error("symbol interface differs"))) when(abcRead dbClose(abcRead)))
      abcEntry['saved]=t abcEntry['stage]="dut_symbol_testbenches_saved" t) t)
    unless(abcResult abcEntry['error]=strcat("Failed at " abcEntry['stage] "; partial target retained; inspect CIW"))
    return(aiRebuildReply(abcEntry))))
procedure(aiRebuildInspect(abiRef)
  prog((abiEntry)
    abiEntry=aiRebuildEntries[abiRef]
    unless(and(abiEntry abiEntry['saved]) return(aiCircuitError("dut_not_saved" "Unknown/incomplete rebuild")))
    unless(car(errset(aiRebuildValidate(abiEntry) t)) return(aiCircuitError("dut_changed" "Source/view/window differs; inspect CIW")))
    return(aiRebuildReply(abiEntry))))
