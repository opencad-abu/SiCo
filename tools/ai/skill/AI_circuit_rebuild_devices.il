; Reference preservation is distinct from a size-change/CDF recalculation flow.
procedure(aiRebuildInst(ariCv ariRow ariName ariLib ariCell ariXy ariOrient)
  prog((cdfgData cdfgForm ariSaved ariMaster ariInst ariParam)
    unwindProtect(progn(
      ariMaster=dbOpenCellViewByType(ariLib ariCell "symbol" "" "r")
      unless(ariMaster error("target master unavailable"))
      cdfgData=cdfGetCellCDF(ddGetObj(ariLib ariCell)) cdfgForm=nil
      ariSaved=foreach(mapcar ariP cdfgData~>parameters list(ariP ariP~>value))
      when(ariLib=="gpdk045"
        unless(and(cdfgData~>formInitProc=="PasCdfFormInit" cdfgData~>doneProc==if(ariCell=="mimcap" nil "PasCdfDone"))
          error("unqualified CDF hooks"))
        PasCdfFormInit(cdfgData))
      foreach(ariPair nth(6 ariRow)
        ariParam=cdfFindParamByName(cdfgData car(ariPair))
        when(ariParam ariParam~>value=cadr(ariPair)))
      ariInst=schCreateInst(ariCv ariMaster ariName ariXy ariOrient)
      unless(ariInst error("instance create failed"))
      foreach(ariP nth(5 ariRow)
        unless(member(cadr(ariP) list("string" "int" "float" "boolean")) error("unsupported source property type"))
        unless(dbReplaceProp(ariInst car(ariP) cadr(ariP) caddr(ariP)) error("source property write failed")))
      unless(equal(aiGateParams(ariInst) nth(6 ariRow)) error("effective CDF differs: %s" ariName)))
      progn(foreach(ariP ariSaved car(ariP)~>value=cadr(ariP)) when(ariMaster dbClose(ariMaster))))
    return(ariInst)))
procedure(aiRebuildPin(arpCv arpPort arpXy)
  let((arpMaster arpFig)
    unwindProtect(progn(
      arpMaster=dbOpenCellViewByType("basic" case(cadr(arpPort) ("input" "ipin") ("output" "opin") (t "iopin")) "symbol" "" "r")
      arpFig=schCreatePin(arpCv arpMaster car(arpPort) cadr(arpPort) nil arpXy "R0")
      unless(arpFig error("pin creation failed"))
      aiGateWire(arpCv list(arpXy list(xCoord(arpXy)+if(cadr(arpPort)=="output" -0.375 0.375) yCoord(arpXy))) caddr(arpPort)))
      when(arpMaster dbClose(arpMaster)))
    t))
procedure(aiRebuildStub(arsCv arsInst arsConn arsDesign)
  prog((arsP arsBox arsDx arsDy arsEnd arsDir arsSegments arsLabelPt)
    arsP=aiRcAnchor(arsInst car(arsConn))
    arsBox=arsInst~>bBox
    arsDx=xCoord(arsP)-(xCoord(car(arsBox))+xCoord(cadr(arsBox)))/2.0
    arsDy=yCoord(arsP)-(yCoord(car(arsBox))+yCoord(cadr(arsBox)))/2.0
    ; Choose outward direction from transformed anchor. Design-symbol pins on
    ; left/right use explicit sides; primitive sources use the larger axis.
    when(arsDesign arsDy=0)
    arsDir=if(abs(arsDx)>=abs(arsDy) then list(if(arsDx<0 -0.375 0.375) 0)
      else list(0 if(arsDy<0 -0.375 0.375)))
    arsEnd=list(xCoord(arsP)+car(arsDir) yCoord(arsP)+cadr(arsDir))
    arsSegments=schCreateWire(arsCv "draw" "full" list(arsP arsEnd) 0.0625 0.0625 0.0)
    unless(arsSegments error("testbench stub failed"))
    arsLabelPt=list(xCoord(arsEnd)+if(car(arsDir)<0 -0.0625 0.0625) yCoord(arsEnd)+0.0625)
    unless(schCreateWireLabel(arsCv car(arsSegments) arsLabelPt cadr(arsConn)
      if(car(arsDir)<0 "lowerRight" "lowerLeft") "R0" "stick" 0.125 nil) error("testbench net label failed"))
    return(t)))
procedure(aiRebuildDut(ardCv ardSpec)
  prog((ardSeen ardSegments ardBox ardXy ardY ardWireMap ardParent)
    foreach(ardRow cadr(ardSpec)
      aiRebuildInst(ardCv ardRow car(ardRow) cadr(ardRow) caddr(ardRow) nth(3 ardRow) nth(4 ardRow)))
    foreach(ardW nth(3 ardSpec)
      ardSegments=schCreateWire(ardCv "draw" "full" cadr(ardW) 0.0625 0.0625 0.0)
      unless(ardSegments error("wire recreation failed"))
      ardWireMap=cons(list(cadr(ardW) car(ardSegments)) ardWireMap)
      unless(member(car(ardW) ardSeen)
        ardBox=car(ardSegments)~>bBox
        ardXy=list((xCoord(car(ardBox))+xCoord(cadr(ardBox)))/2.0+0.0625
          (yCoord(car(ardBox))+yCoord(cadr(ardBox)))/2.0+0.0625)
        unless(schCreateWireLabel(ardCv car(ardSegments) ardXy car(ardW) "lowerLeft" "R0" "stick" 0.0625 nil)
          error("net label failed"))
        ardSeen=cons(car(ardW) ardSeen)))
    foreach(ardLabel nth(5 ardSpec)
      ardParent=assoc(caddr(ardLabel) ardWireMap)
      unless(ardParent error("source label wire missing"))
      unless(schCreateWireLabel(ardCv cadr(ardParent) cadr(ardLabel) car(ardLabel) "lowerLeft" "R0" "stick" 0.0625 nil)
        error("source net label failed")))
    ardY=-0.25
    foreach(ardPort caddr(ardSpec)
      if(cadr(ardPort)=="output" then aiRebuildPin(ardCv ardPort 3:-0.25)
      else aiRebuildPin(ardCv ardPort list(-3.5 ardY)) ardY=ardY-0.5))
    unless(schCreateNoteLabel(ardCv -2:2 "OpAmp | gpdk045 v3.5 | reference parameters" "lowerLeft" "R0" "fixed" 0.125 "normalLabel") error("note failed"))
    return(schCheck(ardCv))))
procedure(aiRebuildTb(artCv artSpec artLib artCell)
  prog((artXy artInst artName artMasterLib artMasterCell artMap artPositions artParam artCaption)
    artPositions=if(car(artSpec)=="OpAmp_AC_top" then
      list(list("I0" 4:0) list("C0" 8:-0.5) list("R0" 10:-0.5) list("I2" 2:-0.5)
        list("FB" 5:-5) list("Vcm" 0:-5) list("V1" 0:-0.5) list("V2" 0:-3)
        list("V0" 2:-3) list("V4" 2:-5) list("I17" 8:-6) list("I1" 10:-6))
      else list(list("I0" 4:0) list("C0" 8:-0.5) list("R0" 10:-0.5) list("I2" 2:-0.5)
        list("Vin" 2:-3) list("VFB" 2:-5) list("V1" 0:-0.5) list("V2" 0:-3) list("I1" 10:-6)))
    foreach(artRow cadr(artSpec)
      artMasterLib=cadr(artRow) artMasterCell=caddr(artRow) artName=car(artRow)
      when(artMasterLib=="Two_Stage_Opamp"
        when(artMasterCell=="OpAmp" artMasterLib=artLib artMasterCell=artCell)
        artName=strcat("I_" artMasterCell "_0"))
      artXy=cadr(assoc(car(artRow) artPositions))
      unless(artXy error("unqualified testbench instance"))
      when(artMasterLib=="analogLib"
        when(member(artMasterCell list("vdc" "vpulse" "idc"))
          unless(xCoord(artXy)<3.0 error("TB stimulus must be left of DUT")))
        when(member(artMasterCell list("cap" "res"))
          unless(xCoord(artXy)>7.0 error("TB load must be right of DUT"))))
      artInst=aiRebuildInst(artCv artRow artName artMasterLib artMasterCell artXy "R0")
      foreach(artConn nth(7 artRow) aiRebuildStub(artCv artInst artConn member(artMasterLib list(artLib "Two_Stage_Opamp"))))
      when(artMasterLib=="analogLib" && artMasterCell!="gnd"
        artParam=case(artMasterCell ("cap" "c") ("res" "r") ("vdc" "vdc") ("idc" "idc"))
        artCaption=if(artParam strcat(artName "=" cadr(assoc(artParam nth(6 artRow)))) strcat(artName " " artMasterCell))
        unless(schCreateNoteLabel(artCv list(xCoord(artXy)+0.25 yCoord(artXy)-0.1875)
          artCaption "lowerLeft" "R0" "fixed" 0.125 "normalLabel") error("device caption failed")))
      artMap=cons(list(car(artRow) artName) artMap))
    unless(schCreateNoteLabel(artCv -1:2 strcat(car(artSpec) " | labelled reference nets") "lowerLeft" "R0" "fixed" 0.125 "normalLabel") error("note failed"))
    foreach(artNote append(list(list(0:1 "Supplies / stimulus") list(4:1 "DUT") list(8:1 "Load"))
      if(car(artSpec)=="OpAmp_AC_top" list(list(4:-3.75 "Feedback / bias")) nil))
      unless(schCreateNoteLabel(artCv car(artNote) cadr(artNote) "lowerLeft" "R0" "fixed" 0.125 "normalLabel") error("group note failed")))
    return(list(schCheck(artCv) artMap))))
procedure(aiRebuildSymbol(absCv absPorts)
  prog((absMaster absY absRight absPoint absInside)
    unwindProtect(progn(
      absMaster=dbOpenCellViewByType("basic" "sympin" "symbolNN" "" "r")
      unless(absMaster error("symbol pin master missing"))
      unless(schCreateSymbolShape(absCv "rectangle" "outline" list(0:-3 2:0.5)) error("symbol outline failed"))
      absY=-0.5
      foreach(absPort absPorts
        absRight=cadr(absPort)=="output"
        absPoint=if(absRight list(2.25 -1.5) list(-0.25 absY))
        unless(absRight absY=absY-0.5)
        absInside=list(if(absRight 2 0) yCoord(absPoint))
        unless(schCreateSymbolPin(absCv absMaster car(absPort) cadr(absPort) absPoint "R0") error("symbol pin failed"))
        unless(schCreateSymbolShape(absCv "line" "outline" list(absPoint absInside)) error("symbol stub failed"))
        unless(schCreateSymbolLabel(absCv list(if(absRight 1.9375 0.0625) yCoord(absPoint))
          "pin name" car(absPort) if(absRight "centerRight" "centerLeft") "R0" "stick" 0.0625 "normalLabel") error("pin name failed"))
        aiCircuitAnalogPinLabel(absCv car(absPort) absPoint absRight))
      schCreateSymbolLabel(absCv 1:0 "symbol shape" "OpAmp" "centerCenter" "R0" "fixed" 0.125 "normalLabel")
      schCreateSymbolLabel(absCv 0:0.75 "instance label" "[@instanceName]" "lowerLeft" "R0" "fixed" 0.125 "NLPLabel")
      aiCircuitCreateSymbolBox(absCv)) when(absMaster dbClose(absMaster)))
    return(t)))
