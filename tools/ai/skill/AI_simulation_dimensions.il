; Explicit shared corner model sets and global numeric list sweeps. No PDK defaults.
procedure(aiSimDimensionPairLess(asdA asdB) alphalessp(car(asdA) car(asdB)))
procedure(aiSimDimensionCount(asdPayload)
  let((asdCount) asdCount=1
    foreach(asdSweep nth(5 asdPayload) asdCount=asdCount*length(caddr(asdSweep))) asdCount))
procedure(aiSimExpected(asdPayload)
  prog((asdRows asdCorners)
    asdCorners=if(nth(4 asdPayload) foreach(mapcar asdC nth(4 asdPayload) car(asdC)) list("nominal"))
    for(asdPoint 1 aiSimDimensionCount(asdPayload)
      foreach(asdName asdCorners foreach(asdTest nth(3 asdPayload)
        asdRows=cons(list(car(asdTest) asdName asdPoint) asdRows))))
    return(reverse(asdRows))))
procedure(aiSimGlobalValues(asdPayload)
  foreach(mapcar asdVar cadr(asdPayload)
    if(assoc(car(asdVar) nth(5 asdPayload))
      list(car(asdVar) cadr(assoc(car(asdVar) nth(5 asdPayload)))) asdVar)))
procedure(aiSimDimensionSnapshot(asdSession)
  prog((asdDb asdCorner asdModel)
    asdDb=axlGetMainSetupDB(asdSession)
    return(foreach(mapcar asdName aiSimSorted(cadr(axlGetCorners(asdDb)))
      asdCorner=axlGetCorner(asdDb asdName)
      list(asdName aiSimSorted(cadr(axlGetCornerDisabledTests(asdCorner)))
        aiSimVars(asdSession asdCorner)
        foreach(mapcar asdVar aiSimSorted(cadr(axlGetVars(asdCorner)))
          list(asdVar when(axlGetEnabled(axlGetVar(asdCorner asdVar)) t)))
        sort(foreach(mapcar asdFile cadr(axlGetModels(asdCorner))
          asdModel=axlGetModel(asdCorner asdFile)
          sprintf(nil "%L" list(asdFile axlGetModelFile(asdModel) axlGetModelSection(asdModel)
            axlGetModelTest(asdModel) axlGetModelBlock(asdModel)))) 'alphalessp))))))
procedure(aiSimConfigureDimensions(asdEntry)
  prog((asdSession asdPayload asdDb asdCorner asdModel asdIndex)
    asdSession=asdEntry['session] asdPayload=asdEntry['payload] asdDb=axlGetMainSetupDB(asdSession)
    foreach(asdRow nth(4 asdPayload)
      unless(maeSetCorner(car(asdRow) ?enabled t
        ?enableTests foreach(mapcar asdTest nth(3 asdPayload) car(asdTest)) ?session asdSession)
        error("corner create failed"))
      asdCorner=axlGetCorner(asdDb car(asdRow)) asdIndex=0
      foreach(asdFile nth(3 asdRow)
        ; Stable distinct keys allow multiple explicitly selected sections of one file.
        asdIndex=asdIndex+1 asdModel=axlPutModel(asdCorner sprintf(nil "model_%d" asdIndex))
        unless(and(asdModel axlSetModelFile(asdModel car(asdFile))) error("corner model failed"))
        when(cadr(asdFile)
          unless(axlSetModelSection(asdModel cadr(asdFile)) error("corner model section failed"))))
      foreach(asdVar cons(list("temperature" cadr(asdRow)) caddr(asdRow))
        unless(maeSetVar(car(asdVar) cadr(asdVar) ?typeName "corner" ?typeValue list(car(asdRow))
          ?session asdSession) error("corner variable failed"))))
    when(nth(4 asdPayload)
      unless(maeSetCorner("Nominal" ?enabled nil ?session asdSession) error("nominal disable failed")))
    foreach(asdSweep nth(5 asdPayload)
      unless(maeSetVar(car(asdSweep) cadr(asdSweep) ?session asdSession) error("global sweep failed")))
    return(t)))
procedure(aiSimReadbackDimensions(asdEntry)
  prog((asdSession asdPayload asdDb asdCorner asdModel asdNames asdIndex asdKeys)
    asdSession=asdEntry['session] asdPayload=asdEntry['payload] asdDb=axlGetMainSetupDB(asdSession)
    asdNames=foreach(mapcar asdRow nth(4 asdPayload) car(asdRow))
    aiSimAssertEqual(aiSimSorted(maeGetSetup(?typeName "corners" ?enabled t ?session asdSession))
      aiSimSorted(or(asdNames list("Nominal"))) "enabled corner names")
    ; Built-in Nominal may be absent from axlGetCorners. Reject other unrequested corners.
    aiSimAssertEqual(aiSimSorted(remove("Nominal" cadr(axlGetCorners(asdDb))))
      aiSimSorted(asdNames) "all explicit corner names")
    foreach(asdRow nth(4 asdPayload)
      asdCorner=axlGetCorner(asdDb car(asdRow))
      foreach(asdVar cadr(axlGetVars(asdCorner))
        unless(axlGetEnabled(axlGetVar(asdCorner asdVar)) error("corner variable disabled")))
      when(cadr(axlGetCornerDisabledTests(asdCorner)) error("corner test unexpectedly disabled"))
      aiSimAssertEqual(aiSimVars(asdSession asdCorner)
        sort(cons(list("temperature" cadr(asdRow)) copy(caddr(asdRow))) 'aiSimDimensionPairLess)
        "corner variables and temperature")
      asdIndex=0 asdKeys=nil
      foreach(asdFile nth(3 asdRow)
        asdIndex=asdIndex+1 asdKeys=cons(sprintf(nil "model_%d" asdIndex) asdKeys)
        asdModel=axlGetModel(asdCorner car(asdKeys))
        unless(asdModel error("corner model missing"))
        aiSimAssertEqual(axlGetModelFile(asdModel) car(asdFile) "corner model path")
        aiSimAssertEqual(or(axlGetModelSection(asdModel) "") or(cadr(asdFile) "") "corner section")
        unless(and(equal(axlGetModelTest(asdModel) "All")
          equal(axlGetModelBlock(asdModel) "Global")) error("model scope is not shared: %L %L" axlGetModelTest(asdModel) axlGetModelBlock(asdModel))))
      aiSimAssertEqual(aiSimSorted(cadr(axlGetModels(asdCorner))) aiSimSorted(asdKeys) "corner model keys"))
    return(t)))
