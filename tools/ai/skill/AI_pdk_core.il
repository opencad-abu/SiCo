; Read-only discovery helpers. Never retain DD/DB/CDF handles across requests.
unless(boundp('aiPdkSessionRef) aiPdkSessionRef=nil)
unless(boundp('aiPdkTransfers) aiPdkTransfers=makeTable("aiPdkTransfers" nil))
unless(boundp('aiPdkTransferCount) aiPdkTransferCount=0)
procedure(aiPdkRevision() "20260923.ai.pdk.v5")
procedure(aiPdkObj(apPairs) cons('pdkJsonObject apPairs))
procedure(aiPdkArray(apValues) cons('pdkJsonArray apValues))
procedure(aiPdkBool(apValue) if(apValue t 'pdkJsonFalse))
procedure(aiPdkJson(apValue)
  let((apParts)
    cond((eq(apValue 'pdkJsonFalse) "false") (eq(apValue t) "true")
      (null(apValue) "null")
      (stringp(apValue) strcat("\"" aiJsonEscape(apValue) "\""))
      (numberp(apValue) if(fixp(apValue) sprintf(nil "%d" apValue) sprintf(nil "%.17g" apValue)))
      (listp(apValue)
        apParts=""
        if(eq(car(apValue) 'pdkJsonObject) then
          foreach(apPair cdr(apValue)
            apParts=strcat(apParts if(apParts=="" "" ",")
              aiPdkJson(car(apPair)) ":" aiPdkJson(cadr(apPair)))
            when(strlen(apParts)>8388608 error("discovery JSON limit")))
          strcat("{" apParts "}")
        else
          foreach(apElement if(eq(car(apValue) 'pdkJsonArray) cdr(apValue) apValue)
            apParts=strcat(apParts if(apParts=="" "" ",") aiPdkJson(apElement))
            when(strlen(apParts)>8388608 error("discovery JSON limit")))
          strcat("[" apParts "]")))
      (t error("Unsupported discovery JSON value")))))
procedure(aiPdkError(apCode apMessage)
  aiPdkJson(aiPdkObj(list(list("ok" 'pdkJsonFalse) list("code" apCode) list("message" apMessage)))))

; Tagged SKILL values: nil/string/symbol/list/number remain distinct. Opaque
; values are reported without printing their process-specific handle addresses.
procedure(aiPdkRaw(apRawValue @optional (apRawDepth 0))
  let((apRawType apRawOut apRawItems apRawTail apRawCount apRawStatus)
    apRawStatus="known"
    cond(
      (null(apRawValue) apRawType="nil")
      (stringp(apRawValue)
        apRawType="string"
        if(strlen(apRawValue)<=8192 then apRawOut=apRawValue
          else apRawStatus="unsupported"))
      (numberp(apRawValue)
        apRawType=if(fixp(apRawValue) "integer" "float") apRawOut=apRawValue)
      (symbolp(apRawValue) apRawType="symbol" apRawOut=symbolToString(apRawValue))
      (and(listp(apRawValue) apRawDepth<10)
        apRawType="list" apRawTail=apRawValue apRawCount=0
        while(and(apRawTail listp(apRawTail) apRawCount<2048)
          apRawItems=cons(aiPdkRaw(car(apRawTail) apRawDepth+1) apRawItems)
          apRawTail=cdr(apRawTail) apRawCount=apRawCount+1)
        if(apRawTail then apRawStatus="unsupported" else apRawOut=aiPdkArray(reverse(apRawItems))))
      (t apRawType="opaque_or_limit" apRawStatus="unsupported"))
    aiPdkObj(list(list("type" apRawType) list("status" apRawStatus) list("value" apRawOut)))))

procedure(aiPdkAttrs(apAttrObj apAttrExcluded)
  let((apAttrKeys apAttrResult apAttrPairs)
    apAttrKeys=get(apAttrObj '?)
    when(length(apAttrKeys)>256 error("attribute limit"))
    foreach(apAttrKey sort(copy(apAttrKeys) 'alphalessp)
      unless(member(apAttrKey apAttrExcluded)
        apAttrResult=errset(get(apAttrObj apAttrKey) nil)
        apAttrPairs=cons(list(symbolToString(apAttrKey)
          if(apAttrResult then aiPdkRaw(car(apAttrResult))
            else aiPdkObj(list(list("type" "unavailable") list("status" "unavailable") list("value" nil)))))
          apAttrPairs)))
    aiPdkObj(reverse(apAttrPairs))))

procedure(aiPdkSection(apStatus apSource apItems @optional apIssues)
  aiPdkObj(list(list("status" apStatus) list("source" apSource)
    list("items" aiPdkArray(apItems)) list("issues" aiPdkArray(apIssues)))))

procedure(aiPdkLibrary(apLib)
  let((apTech apTechResult apLibPath)
    apLibPath=ddGetObjReadPath(apLib)
    apTechResult=errset(techGetTechLibName(apLib) nil)
    when(apTechResult apTech=car(apTechResult))
    aiPdkObj(list(list("name" apLib~>name) list("resolved_path" apLibPath)
      list("status" if(apLibPath "complete" "unavailable"))
      list("technology_library" apTech)
      list("technology_status" if(apTechResult "known" "unavailable"))
      list("pdk_ref" nil) list("pdk_version" nil) list("pdk_status" "unknown")
      list("source" "ddGetLibList/ddGetObj/ddGetObjReadPath;techGetTechLibName")))))

procedure(aiPdkContext(apProposedRef @optional (apContextSource "current_process_via_existing_session_bridge"))
  let((apLibraries apLibraryIds apWorkspace apBridgeGeneration)
    unless(aiPdkSessionRef aiPdkSessionRef=apProposedRef)
    when(boundp('aiIpcState)
      apBridgeGeneration=aiIpcState['generation]
      apWorkspace=aiIpcState['workspace])
    apLibraryIds=ddGetLibList()
    when(length(apLibraryIds)>4096 error("library binding limit"))
    foreach(apLibraryId apLibraryIds apLibraries=cons(aiPdkLibrary(apLibraryId) apLibraries))
    aiPdkObj(list(list("session_ref" aiPdkSessionRef)
      list("bridge_generation" apBridgeGeneration) list("collector_revision" aiPdkRevision())
      list("process_id" ipcGetPid()) list("virtuoso_version" getVersion(t))
      list("cadence_install_path" car(getInstallPath()))
      list("working_directory" getWorkingDir()) list("workspace" apWorkspace)
      list("captured_at_cadence" getCurrentTime()) list("libraries" aiPdkArray(apLibraries))
      list("source" apContextSource)))))
