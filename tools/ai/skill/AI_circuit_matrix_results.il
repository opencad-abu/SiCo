; Each row carries actual RDB coordinates; never assume corner/point ordering.
procedure(aiMatrixParam(ampCorner ampName)
  prog((ampValues)
    ampValues=setof(ampP ampCorner->params() ampP->name==ampName)
    unless(length(ampValues)==1 error("missing/duplicate matrix parameter: %s" ampName))
    return(car(ampValues)->value)))
procedure(aiMatrixMatch(ammValue ammExpected)
  prog((ammMatches)
    unless(numberp(ammValue) error("non-numeric load parameter"))
    ammMatches=setof(ammV ammExpected abs(ammValue-ammV)<=max(abs(ammV)*1e-12 1e-30))
    unless(length(ammMatches)==1 error("unexpected load parameter"))
    return(car(ammMatches))))
procedure(aiMatrixScalar(amsValue)
  and(numberp(amsValue) amsValue==amsValue abs(amsValue)<1e300))
procedure(aiMatrixResults(amrRef)
  prog((amrRun amrResult amrSession amrEntry amrDb amrRows amrKeys amrCap amrRes
    amrExpected amrOutputs amrMatches amrValue amrScalar amrComplete amrKey)
    amrRun=aiOpampRuns[amrRef]
    unless(and(amrRun amrRun['matrix]) return(aiCircuitError("matrix_run_required" "Unknown matrix run")))
    when(amrRun['results] return(amrRun['results]))
    aiOpampStatus(amrRef)
    unless(amrRun['state]=="completed" return(aiCircuitError("run_not_completed" "Matrix run has not completed")))
    amrResult=errset(progn(
      amrEntry=aiOpampEntries[amrRun['setup]] amrSession=aiOpampSession(amrEntry)
      unless(amrSession==amrRun['session] error("matrix session changed"))
      amrDb=maeReadResDB(?session amrSession ?historyName amrRun['history])
      amrExpected=length(car(amrRun['matrix]))*length(cadr(amrRun['matrix]))
      unless(and(amrDb length(amrDb->points())==amrExpected) error("matrix point count differs"))
      amrComplete=t
      foreach(amrPoint amrDb->points()
        unless(equal(sort(foreach(mapcar amrC amrPoint->corners() amrC->name) 'alphalessp) list("ff" "ss" "tt"))
          error("matrix corners differ"))
        foreach(amrCorner amrPoint->corners()
          amrCap=aiMatrixMatch(aiMatrixParam(amrCorner "cload") car(amrRun['matrix]))
          amrRes=aiMatrixMatch(aiMatrixParam(amrCorner "rload") cadr(amrRun['matrix]))
          unless(and(aiMatrixParam(amrCorner "temperature")==27 aiMatrixParam(amrCorner "vdd")==1.3
            aiMatrixParam(amrCorner "nomGain")==0 equal(aiMatrixParam(amrCorner "corModelSpec")
              list(list(strcat(amrEntry['root] "/models/spectre/gpdk045.scs") amrCorner->name))))
            error("actual model/operating condition differs"))
          amrKey=list(amrCorner->name amrCap amrRes)
          when(member(amrKey amrKeys) error("duplicate matrix coordinate")) amrKeys=cons(amrKey amrKeys)
          amrOutputs=amrCorner->outputs(?type 'expr)
          foreach(amrSpec aiOpampMeasurements()
            amrMatches=setof(amrO amrOutputs and(amrO->testName==car(amrSpec) amrO->name==cadr(amrSpec)
              amrO->cornerName==amrCorner->name amrO->pointID==amrPoint->id))
            unless(length(amrMatches)<=1 error("duplicate matrix measurement"))
            amrValue=if(amrMatches car(amrMatches)->value nil) amrScalar=aiMatrixScalar(amrValue)
            unless(amrScalar amrComplete=nil)
            amrRows=cons(list(car(amrSpec) cadr(amrSpec) amrCorner->name amrPoint->id amrCap amrRes
              if(amrScalar amrValue nil) caddr(amrSpec) if(amrScalar "measured" "missing_or_non_scalar")) amrRows))))
      unless(length(amrKeys)==3*amrExpected error("incomplete matrix coordinates"))
      amrRun['results]=aiCircuitObject(list(list("ok" t) list("run_ref" amrRef) list("history" amrRun['history])
        list("all_scalar" aiCircuitBool(amrComplete)) list("spec_qualified" 'jsonFalse)
        list("columns" list("test" "output" "corner" "point" "cload_f" "rload_ohm" "value" "unit" "status"))
        list("rows" reverse(amrRows)) list("source" "maeReadResDB") list("temperature_c" 27)
        list("unit_source" "fixed_reference_measurement_recipe"))) t) t)
    unless(amrResult return(aiCircuitError("matrix_results_unavailable" "Unexpected/missing RDB matrix coordinates; inspect CIW")))
    return(amrRun['results])))
