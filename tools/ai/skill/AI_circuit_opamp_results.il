; Fixed reference measurements. Spec pass and simulation completion stay separate.
procedure(aiOpampMeasurements()
  list(list("AC" "Current" "A") list("AC" "UGF" "Hz") list("AC" "Gain" "dB")
    list("AC" "Voffset" "V") list("AC" "nomGain" "dB") list("TRAN" "Swing" "V")
    list("TRAN" "SettlingTime" "s") list("TRAN" "RelativeSwingPercent" "%")
    list("TRAN" "PhaseMargin" "deg")))
procedure(aiOpampResults(aorRef)
  prog((aorRun aorDb aorPoint aorOutputs aorMatches aorValue aorRows aorResult aorComplete aorOut aorScalar)
    aorRun=aiOpampRuns[aorRef]
    unless(aorRun return(aiCircuitError("run_not_found" "Unknown reference run")))
    when(aorRun['matrix] return(aiMatrixResults(aorRef)))
    when(aorRun['results] return(aorRun['results]))
    aiOpampStatus(aorRef)
    unless(aorRun['state]=="completed" return(aiCircuitError("run_not_completed" "Reference run has not completed")))
    aorResult=errset(progn(
      unless(aiOpampSession(aiOpampEntries[aorRun['setup]])==aorRun['session] error("session changed"))
      aorDb=maeReadResDB(?session aorRun['session] ?historyName aorRun['history])
      unless(and(aorDb length(aorDb->points())==1) error("unexpected reference points"))
      aorPoint=car(aorDb->points())
      unless(and(aorPoint->id==1 length(aorPoint->corners())==1) error("unexpected point/corner dimensions"))
      aorOutputs=aorPoint->outputs(?type 'expr) aorComplete=t
      foreach(aorSpec aiOpampMeasurements()
        aorMatches=setof(aorCandidate aorOutputs and(aorCandidate->testName==car(aorSpec)
          aorCandidate->name==cadr(aorSpec) aorCandidate->cornerName=="nominal"))
        unless(length(aorMatches)<=1 error("duplicate reference measurement"))
        aorOut=car(aorMatches) aorValue=if(aorOut aorOut->value nil)
        aorScalar=and(numberp(aorValue) aorValue==aorValue abs(aorValue)<1e300)
        unless(aorScalar aorComplete=nil)
        aorRows=cons(list(car(aorSpec) cadr(aorSpec) "nominal" aorPoint->id
          if(aorScalar aorValue nil) caddr(aorSpec) if(aorScalar "measured" "missing_or_non_scalar")
          if(aorScalar nil substring(sprintf(nil "%L" aorValue) 1 min(160 strlen(sprintf(nil "%L" aorValue)))))) aorRows))
      aorRun['results]=aiCircuitObject(list(list("ok" t) list("run_ref" aorRef)
        list("history" aorRun['history]) list("all_scalar" aiCircuitBool(aorComplete))
        list("spec_qualified" 'jsonFalse) list("unit_source" "fixed_reference_measurement_recipe")
        list("columns" list("test" "output" "corner" "point" "value" "unit" "status" "raw"))
        list("rows" reverse(aorRows)) list("source" "maeReadResDB"))) t) t)
    unless(aorResult return(aiCircuitError("results_unavailable" "Reference RDB unavailable/unexpected dimensions; inspect CIW")))
    return(aorRun['results])))
