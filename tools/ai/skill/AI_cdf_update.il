; Retained, single-instance CDF writes. No base/user CDF definition is saved.
unless(boundp('aiCdfUpdates) aiCdfUpdates=makeTable("aiCdfUpdates" nil))
procedure(aiCdfUpdateCheck(acuEntry)
  prog((acuCv acuInst acuCdf)
    unless(and(acuEntry aiCircuitTasks[acuEntry['task]]==acuEntry['mode]) error("CDF update task changed"))
    when(and(boundp('aiCopilotSource) aiCopilotSource) aiCopilotTaskCheck(acuEntry['task]))
    unless(equal(aiCdfSnapshot(acuEntry['target] acuEntry['instance]) acuEntry['capture])
      error("CDF capture or instance changed; inspect again"))
    unwindProtect(progn(
      acuCv=apply('dbOpenCellViewByType append(acuEntry['target] list("" "r")))
      unless(and(acuCv !dbIsCellViewModified(acuCv) ddIsObjWritable(apply('ddGetObj acuEntry['target]))
        equal(aiCrSnapshot(acuCv) acuEntry['snapshot])) error("Schematic changed or is not writable"))
      acuInst=dbFindAnyInstByName(acuCv acuEntry['instance])
      acuCdf=cdfGetCellCDF(ddGetObj(acuInst~>libName acuInst~>cellName))
      unless(equal(aiCdfSourceState(acuCdf) acuEntry['source]) error("Source CDF changed"))
      unless(equal(aiCdfCallbackEvidence(acuCdf acuEntry['rows]) acuEntry['procedures])
        error("CDF callback procedures changed")))
      when(acuCv dbClose(acuCv)))
    return(t)))
procedure(aiCdfUpdatePrepare(acuRef acuTask acuId acuRows)
  prog((acuCapture acuCv acuInst acuEntry acuResult acuPrepare acuRecord)
    acuPrepare=strcat("cdf-update-prepare:" acuId)
    acuRecord=aiRcReserve(acuPrepare list(acuRef acuTask acuRows))
    when(acuRecord['reply] return(acuRecord['reply]))
    acuResult=errset(unwindProtect(progn(
      acuCapture=aiCdfCaptures[acuRef]
      unless(and(acuCapture cadr(acuCapture) eq(nth(4 acuCapture) 'jsonFalse)
        member(aiCircuitTasks[acuTask] list("foreground" "background")))
        error("Fresh saved instance CDF and confirmed task required"))
      unless(equal(aiCdfSnapshot(car(acuCapture) cadr(acuCapture)) acuCapture) error("Stale instance CDF"))
      unless(simplifyFilename(nth(3 acuCapture))!=simplifyFilename(nth(9 acuCapture))
        error("Cannot update instances in the device master library"))
      acuCv=apply('dbOpenCellViewByType append(car(acuCapture) list("" "r")))
      acuInst=dbFindAnyInstByName(acuCv cadr(acuCapture))
      aiCdfCallbackValidate(acuInst~>master acuRows)
      foreach(acuProp acuInst~>prop
        unless(member(acuProp~>valueType list("string" "int" "float" "boolean"))
          error("Instance has unsupported property restoration type")))
      acuEntry=makeTable("aiCdfUpdate" nil)
      acuEntry['prepare]=acuPrepare acuEntry['task]=acuTask acuEntry['mode]=aiCircuitTasks[acuTask]
      acuEntry['target]=car(acuCapture) acuEntry['instance]=cadr(acuCapture)
      acuEntry['capture]=acuCapture acuEntry['rows]=acuRows acuEntry['snapshot]=aiCrSnapshot(acuCv)
      acuEntry['restorationSnapshot]=aiCrSnapshot(acuCv t)
      acuEntry['structure]=aiCrSnapshot(acuCv t acuInst)
      acuEntry['source]=aiCdfSourceState(cdfGetCellCDF(ddGetObj(acuInst~>libName acuInst~>cellName)))
      acuEntry['procedures]=aiCdfCallbackEvidence(cdfGetCellCDF(ddGetObj(acuInst~>libName acuInst~>cellName)) acuRows)
      aiCdfUpdates[acuPrepare]=acuEntry
      aiCdfUpdateCheck(acuEntry) t)
      when(acuCv dbClose(acuCv))) t)
    acuRecord['reply]=if(acuResult
      aiCircuitObject(list(list("ok" t) list("prepare_ref" acuPrepare) list("target" acuEntry['target])
        list("instance" acuEntry['instance]) list("callback_order" mapcar('car acuRows))
        list("callbacks_executed" 'jsonFalse) list("next_action" "execute_circuit_operation")))
      aiCircuitError("cdf_update_preflight_failed" aiCdfErrorText()))
    return(acuRecord['reply])))
procedure(aiCdfUpdateReply(acuEntry)
  aiCircuitObject(list(list("ok" aiCircuitBool(!acuEntry['error]))
    list("update_ref" acuEntry['ref]) list("target" acuEntry['target])
    list("instance" acuEntry['instance]) list("task_ref" acuEntry['task])
    list("stage" acuEntry['stage]) list("error" acuEntry['error])
    list("saved" aiCircuitBool(acuEntry['saved])) list("readback_verified" aiCircuitBool(acuEntry['verified]))
    list("backup" acuEntry['backup]) list("parameter_changes" acuEntry['changes])
    list("callback_order" mapcar('car acuEntry['rows]))
    list("callback_execution_attempted" aiCircuitBool(acuEntry['attempted]))
    list("instance_properties_restored" acuEntry['restored])
    list("cdf_values_restored" acuEntry['valuesRestored])
    list("cdf_metadata_unchanged" acuEntry['metadataUnchanged])
    list("failure_parameter" when(acuEntry['error] acuEntry['parameter]))
    list("gui_conditions_evaluated" 'jsonFalse)
    list("side_effect_scope" "instance properties and shared CDF values; other PDK procedure effects are not rolled back"))))
procedure(aiCdfUpdateApply(acuPrepare acuId)
  prog((acuPrepared acuRecord acuEntry acuResult acuCv acuInst acuProps acuBefore acuAfter acuRead acuBackup acuError)
    unless(and(boundp('aiProjectDispatchKey) aiProjectDispatchKey==strcat("cdf-update:" acuId)
      aiProjectClaims[aiProjectDispatchKey] aiProjectDispatchDigest==aiProjectClaims[aiProjectDispatchKey])
      return(aiCircuitError("cdf_update_claim_required" "Use execute_circuit_operation for CDF updates")))
    acuRecord=aiRcReserve(strcat("cdf-update:" acuId) list(acuPrepare))
    when(acuRecord['entry] return(aiCdfUpdateReply(acuRecord['entry])))
    acuPrepared=aiCdfUpdates[acuPrepare]
    acuEntry=makeTable("aiCdfUpdateResult" nil)
    acuEntry['ref]=strcat("cdf-update:" acuId) acuEntry['stage]="preflight"
    when(acuPrepared
      foreach(acuKey list('task 'mode 'target 'instance 'rows) acuEntry[acuKey]=acuPrepared[acuKey]))
    acuRecord['entry]=acuEntry
    acuResult=errset(unwindProtect(progn(
      aiCdfUpdateCheck(acuPrepared)
      acuCv=apply('dbOpenCellViewByType append(acuEntry['target] list("" "a")))
      unless(and(acuCv acuCv~>mode!="r" !dbIsCellViewModified(acuCv)) error("Schematic is not safely editable"))
      acuInst=dbFindAnyInstByName(acuCv acuEntry['instance])
      acuProps=foreach(mapcar acuProp acuInst~>prop list(acuProp~>name acuProp~>valueType acuProp~>value))
      acuBefore=aiCdfValues(cdfGetInstCDF(acuInst))
      acuEntry['stage]="backup"
      acuRead=strcat("cdf_backup_" acuId)
      when(ddGetObj(car(acuEntry['target]) cadr(acuEntry['target]) acuRead) error("CDF backup already exists"))
      acuBackup=dbCopyCellView(acuCv car(acuEntry['target]) cadr(acuEntry['target]) acuRead)
      unless(and(acuBackup dbSave(acuBackup) equal(aiCrSnapshot(acuCv) aiCrSnapshot(acuBackup)))
        error("Could not verify CDF update backup"))
      acuEntry['backup]=list(car(acuEntry['target]) cadr(acuEntry['target]) acuRead)
      dbClose(acuBackup) acuBackup=nil
      acuEntry['stage]="callbacks" acuEntry['attempted]=t
      aiCdfCallbackApply(acuInst acuInst~>master acuEntry['rows] nil nil nil nil acuEntry)
      unless(equal(aiCrSnapshot(acuCv t acuInst) acuPrepared['structure])
        error("CDF callback modified content outside the selected instance parameters"))
      acuAfter=aiCdfValues(cdfGetInstCDF(acuInst))
      acuEntry['changes]=foreach(mapcar acuValue setof(acuV acuAfter !equal(assoc(car(acuV) acuBefore) acuV))
        list(car(acuValue) cadr(assoc(car(acuValue) acuBefore)) cadr(acuValue)))
      acuEntry['stage]="save"
      unless(dbSave(acuCv) error("CDF update save failed")) acuEntry['saved]=t
      dbClose(acuCv) acuCv=nil
      acuEntry['stage]="saved_readback"
      acuCv=apply('dbOpenCellViewByType append(acuEntry['target] list("" "r")))
      unless(equal(acuAfter aiCdfValues(cdfGetInstCDF(dbFindAnyInstByName(acuCv acuEntry['instance]))))
        error("Saved CDF readback differs"))
      unless(equal(aiCrSnapshot(acuCv t dbFindAnyInstByName(acuCv acuEntry['instance])) acuPrepared['structure])
        error("Saved schematic structure differs"))
      acuEntry['verified]=t acuEntry['stage]="cdf_update_saved" t)
      progn(
        acuEntry['failureDetail]=aiCdfErrorText()
        when(and(acuCv acuEntry['attempted] !acuEntry['saved])
          acuError=errset(progn(
            foreach(acuProp acuInst~>prop dbDeletePropByName(acuInst acuProp~>name))
            foreach(acuProp acuProps dbReplaceProp(acuInst car(acuProp) cadr(acuProp) caddr(acuProp)))
            acuEntry['restored]=aiCircuitBool(equal(aiCrSnapshot(acuCv t) acuPrepared['restorationSnapshot]))) t)
          unless(acuError acuEntry['restored]='jsonFalse))
        when(acuBackup dbClose(acuBackup))
        when(acuCv
          if(and(acuEntry['attempted] !acuEntry['saved]) then acuEntry['partialCv]=acuCv else dbClose(acuCv))))) t)
    unless(acuResult acuEntry['error]=strcat("Failed at " acuEntry['stage] ": " or(acuEntry['failureDetail] aiCdfErrorText())))
    return(aiCdfUpdateReply(acuEntry))))
