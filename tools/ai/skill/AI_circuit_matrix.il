; New matrix work copy; existing reference/rebuilt setup remains unchanged.
procedure(aiMatrixRevision() "20260910.ai.matrix.v1")
procedure(aiMatrixSnapshot(amsSession)
  let((amsDb amsCorner amsModel)
    amsDb=axlGetMainSetupDB(amsSession)
    list(axlGetAllSweepsEnabled(amsDb)
      foreach(mapcar amsName cadr(axlGetCorners(amsDb))
        amsCorner=axlGetCorner(amsDb amsName)
        list(amsName axlGetCornerDisabledTests(amsCorner)
          foreach(mapcar amsVar cadr(axlGetVars(amsCorner))
            list(amsVar axlGetVarValue(axlGetVar(amsCorner amsVar))))
          foreach(mapcar amsFile cadr(axlGetModels(amsCorner))
            amsModel=axlGetModel(amsCorner amsFile)
            list(amsFile axlGetModelFile(amsModel) axlGetModelSection(amsModel)
              axlGetModelTest(amsModel) axlGetModelBlock(amsModel))))))))
procedure(aiMatrixValues(amvValues amvMin amvMax)
  unless(and(listp(amvValues) 1<=length(amvValues) length(amvValues)<=4) error("matrix size invalid"))
  foreach(amvValue amvValues
    unless(and(numberp(amvValue) amvValue==amvValue amvMin<=amvValue amvValue<=amvMax
      length(setof(amvV amvValues abs(amvV-amvValue)<=max(abs(amvValue)*1e-12 1e-30)))==1)
      error("matrix value invalid/indistinguishable"))) t)
procedure(aiMatrixValidate(amvEntry)
  let((amvSession)
    amvSession=amvEntry['session]
    unless(equal(aiMatrixSnapshot(amvSession) amvEntry['matrixSnapshot]) error("corner/sweep settings changed"))
    unless(equal(aiRebuildSources() amvEntry['matrixSources]) error("matrix source hierarchy changed"))
    unless(and(simplifyFilename(ddGetObj(car(amvEntry['target]))~>readPath)==amvEntry['matrixWorkPath]
      simplifyFilename(ddGetObj("gpdk045")~>readPath)==simplifyFilename(strcat(amvEntry['root] "/gpdk045"))
      simplifyFilename(ddGetObj("Two_Stage_Opamp")~>readPath)==amvEntry['matrixSourcePath]) error("matrix library path changed"))
    t))
procedure(aiMatrixConfigure(amcEntry)
  let((amcSession amcDb amcCorner amcModel amcFile)
    amcSession=amcEntry['session] amcDb=axlGetMainSetupDB(amcSession)
    amcFile=strcat(amcEntry['root] "/models/spectre/gpdk045.scs")
    ; Delete only corners in this new work copy, including inactive RAK experiments.
    foreach(amcName cadr(axlGetCorners(amcDb))
      unless(maeDeleteCorner(amcName ?session amcSession) error("old copy corner removal failed")))
    foreach(amcName list("tt" "ff" "ss")
      unless(maeSetCorner(amcName ?enabled t ?enableTests list("AC" "TRAN") ?session amcSession) error("corner failed"))
      amcCorner=axlGetCorner(amcDb amcName)
      amcModel=axlPutModel(amcCorner "gpdk045.scs")
      unless(and(amcModel axlSetModelFile(amcModel amcFile) axlSetModelSection(amcModel amcName)) error("model failed"))
      unless(maeSetVar("temperature" "27" ?typeName "corner" ?typeValue list(amcName) ?session amcSession) error("temperature failed")))
    unless(maeSetCorner("Nominal" ?enabled nil ?session amcSession) error("nominal disable failed"))
    foreach(amcPair list(list("cload" car(amcEntry['matrix])) list("rload" cadr(amcEntry['matrix])))
      unless(maeSetVar(car(amcPair) buildString(foreach(mapcar amcV cadr(amcPair) sprintf(nil "%.15g" float(amcV))) " ")
        ?session amcSession) error("sweep values failed")))
    unless(and(maeSetSetup(?variables list("cload" "rload") ?enabled t ?session amcSession)
      axlSetAllSweepsEnabled(amcDb t)) error("sweep enable failed"))
    unless(equal(maeGetSetup(?typeName "corners" ?enabled t ?session amcSession) list("tt" "ff" "ss")) error("enabled corners differ")) t))
procedure(aiMatrixCreate(amcRef amcRequest amcCell amcRoot amcCaps amcRes)
  prog((amcSource amcRecord amcEntry amcSession amcOwned amcResult amcTarget amcSourceCorners amcSuccess)
    amcSource=aiOpampEntries[amcRef]
    unless(and(amcSource !amcSource['matrix]) return(aiCircuitError("source_setup_required" "Use a nominal reference or rebuilt setup")))
    amcResult=errset(aiRcReserve(strcat("matrix:" amcRequest) list(amcRef amcCell amcRoot amcCaps amcRes)) nil)
    unless(amcResult return(aiCircuitError("request_conflict_or_limit" "Matrix request conflict/limit")))
    amcRecord=car(amcResult) when(amcRecord['entry] return(aiOpampReply(amcRecord['entry])))
    amcEntry=makeTable("aiMatrixEntry" nil) amcRecord['entry]=amcEntry
    amcEntry['ref]=strcat("matrix:" amcRequest) aiOpampEntries[amcEntry['ref]]=amcEntry
    foreach(amcKey list('task 'mode 'root 'rebuild 'designSnapshot 'configs) amcEntry[amcKey]=amcSource[amcKey])
    amcTarget=list(car(amcSource['target]) amcCell "maestro") amcEntry['target]=amcTarget
    amcEntry['matrix]=list(amcCaps amcRes) amcEntry['stage]="matrix_preflight"
    amcResult=errset(unwindProtect(progn(
      unless(amcRoot==amcSource['root] error("model root differs"))
      aiMatrixValues(amcCaps 1e-15 1e-10) aiMatrixValues(amcRes 100 1e6)
      aiOpampValidate(amcSource) aiOpampNoActive(amcRef) aiOpampIdle(amcSource['session])
      when(ddGetObj(car(amcTarget) amcCell) error("new matrix cell required"))
      amcSourceCorners=aiMatrixSnapshot(amcSource['session])
      amcEntry['matrixSources]=aiRebuildSources()
      amcEntry['matrixWorkPath]=simplifyFilename(ddGetObj(car(amcTarget))~>readPath)
      amcEntry['matrixSourcePath]=simplifyFilename(ddGetObj("Two_Stage_Opamp")~>readPath)
      amcEntry['stage]="matrix_save_as"
      unless(maeSaveSetup(?lib car(amcTarget) ?cell amcCell ?view "maestro" ?session amcSource['session]) error("matrix Save As failed"))
      aiOpampValidate(amcSource)
      unless(equal(aiMatrixSnapshot(amcSource['session]) amcSourceCorners) error("source corners changed during Save As"))
      amcSession=maeOpenSetup(car(amcTarget) amcCell "maestro" ?application "Assembler" ?mode "a")
      unless(amcSession error("matrix copy open failed")) amcOwned=t amcEntry['session]=amcSession
      amcEntry['stage]="matrix_configure" aiMatrixConfigure(amcEntry)
      unless(maeSaveSetup(?session amcSession) error("matrix save failed"))
      unless(maeCloseSession(?session amcSession) error("matrix bootstrap close failed")) amcSession=nil amcOwned=nil
      if(amcEntry['mode]=="foreground" then
        amcEntry['window]=deOpenCellView(car(amcTarget) amcCell "maestro" "maestro" nil "a")
        aiCircuitPlaceRightHalf(amcEntry['window])
        aiCircuitRaiseWindow(amcEntry['window])
        amcSession=axlGetWindowSession(amcEntry['window])
      else amcSession=maeOpenSetup(car(amcTarget) amcCell "maestro" ?application "Assembler" ?mode "a") amcOwned=t)
      unless(amcSession error("matrix final session failed")) amcEntry['session]=amcSession
      unless(maeSaveSetup(?session amcSession) error("matrix normalization save failed"))
      amcEntry['setupSnapshot]=aiOpampSetupSnapshot(amcSession)
      amcEntry['matrixSnapshot]=aiMatrixSnapshot(amcSession)
      amcEntry['saved]=t aiOpampValidate(amcEntry)
      aiOpampValidate(amcSource)
      unless(equal(aiMatrixSnapshot(amcSource['session]) amcSourceCorners) error("source corners changed during matrix creation"))
      amcEntry['stage]="matrix_saved" amcSuccess=t)
      when(and(amcOwned amcSession !amcSuccess)
        when(maeCloseSession(?session amcSession ?forceClose t) amcEntry['session]=nil))) t)
    unless(amcResult amcEntry['error]=strcat("Failed at " amcEntry['stage] "; partial new target retained; inspect CIW"))
    return(aiOpampReply(amcEntry))))
procedure(aiMatrixInspect(amiRef)
  if(and(aiOpampEntries[amiRef] aiOpampEntries[amiRef]['matrix]) then aiOpampInspect(amiRef)
    else aiCircuitError("matrix_setup_required" "Unknown matrix setup")))
procedure(aiMatrixRun(amrRef amrRequest amrRoot)
  if(and(aiOpampEntries[amrRef] aiOpampEntries[amrRef]['matrix]) then aiOpampRun(amrRef amrRequest amrRoot)
    else aiCircuitError("matrix_setup_required" "Unknown matrix setup")))
