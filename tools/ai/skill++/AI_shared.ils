; Generated by tools/utility/skill_loader.py --write; edit the manifest/sources.
; Source-only. Per-file contracts retain successful members across retries.
set('aiSharedLoaderVersion nil)
let((entryDirectory)
  entryDirectory=strcat("/" buildString(reverse(cdr(reverse(
    parseString(simplifyFilename(get_filename(piport) t) "/")))) "/"))
  load(strcat(entryDirectory "/../../../scripts/sicoSkillLoader.ils"))
  load(strcat(entryDirectory "/../../../scripts/sicoSource.il"))
  SICO_sourceRequire("ai_shared" "3423d38be853962c53eb089c7b8946cdd85ccd3af5d91d510c4753a7b76a00ab" '(
    ("tools/ai/skill" "AI_protocol.il" "6782523a846c6ad18c02f26d7ccd85a400e7fe5a00124350fa7e3d58e963a2ee"
      (aiJsonWhitespaceP aiJsonSkipWhitespace aiJsonParseString aiJsonValidateRequest aiJsonParseRequest
       aiJsonEscape aiProtocolRevision)
      ((aiProtocolRevision "20260909.ai.protocol.v4"))
      (aiProtocolVersion)
      ())
    ("tools/ai/skill" "AI_eval.il" "ee818c77c85ba593e98aeb0d557c829f1aaab30852b067b2b0b6ff3fb41ba281"
      (aiReadTextFile aiWriteTextFile aiEvalTextPrefix aiBoundResultText aiWriteEvalResult
       aiEvalNativeExpression aiEvalFlushWarnings aiEvalCaptureCall aiEvalCapture aiEvalExpression
       aiLoadSkillFile aiWorkingDirectory aiCellViewJson aiGetContext aiEvaluatorRevision)
      ((aiEvaluatorRevision "20260922.ai.eval.v5"))
      (aiEvaluatorVersion)
      ())
    ("tools/ai/skill" "AI_inspect_values.il" "873eafde17d92ad6bfcd29c057f717982cc44f3708e1a2b2d651fd380080e12e"
      (aiInspectMaxItems aiInspectNewBudget aiInspectNewSnapshotBudget aiInspectText aiInspectJsonString
       aiInspectJsonNullableString aiInspectJsonNumber aiInspectJsonBoolean aiInspectAppendJson
       aiInspectPointJson aiInspectBBoxJson aiInspectLppJson aiInspectCellViewJson
       aiInspectCellViewModifiedJson aiInspectOpenTarget aiInspectCloseTarget aiInspectError
       aiInspectTargetError)
      ()
      (aiInspectVersion)
      ())
    ("tools/ai/skill" "AI_inspect_records.il" "2735e4b83d6f83d6d81201e5ffc335d2c65070a45fdc6ff44e100acbbb2615dc"
      (aiInspectPlacementJson aiInspectInstTermJson aiInspectTerminalPinJson
       aiInspectSchematicInstanceJson aiInspectNetJson aiInspectTerminalJson aiInspectLayoutShapeJson
       aiInspectLayoutInstanceJson)
      ()
      (aiInspectVersion)
      ())
    ("tools/ai/skill" "AI_inspect_snapshot.il" "7b0ebe60fc832423a14919b19ab4dec6b7f012cdd7a20908beffe115a6cd03b5"
      (aiInspectSnapshotHeaderJson aiInspectSnapshotWriteLine aiSnapshotSchematic)
      ()
      (aiInspectVersion)
      ())
    ("tools/ai/skill" "AI_inspect.il" "e67ecae612aa6f1ed25755c345922f5a2973bbe86d7393249c633a9acfdd6f5b"
      (aiInspectSchematic aiInspectLayout aiInspectSymbolPorts aiListLibraries aiInspectLibrary
       aiInspectConfigListJson aiInspectConfigBinding aiListWindows aiInspectMasterEscape
       aiInspectMasterOnBoundary aiInspectMasterViews aiInspectMasterPointJson aiInspectMasterBBoxJson
       aiInspectMasterPinsJson aiInspectMasterTerminalsJson aiInspectMasterRow aiInspectMasterEvidence
       aiInspectRevision)
      ((aiInspectRevision "20261022.ai.inspect.v11"))
      (aiInspectVersion)
      ())
    ("tools/ai/skill" "AI_pdk_core.il" "cc19e0ac138a429cd122d31e5a0efc8edc6c6cb3225e40ab849d877cdc19d1f2"
      (aiPdkRevision aiPdkObj aiPdkArray aiPdkBool aiPdkJson aiPdkError aiPdkRaw aiPdkAttrs aiPdkSection
       aiPdkLibrary aiPdkContext)
      ((aiPdkRevision "20260923.ai.pdk.v5"))
      ()
      ())
    ("tools/ai/skill" "AI_pdk_init.il" "dbffc88569375b6f97ba5ffcd089615cc715229381962c3b6d2c6fddb2e1d527"
      (aiPdkInitRevision aiPdkInitLibrary aiPdkInitializeLibrary)
      ((aiPdkInitRevision "20260919.ai.pdk.init.v1"))
      ()
      ())
    ("tools/ai/skill" "AI_pdk_cdf.il" "71b66046dbed979c59ad40c7dbe63a5fa7fe3ea850cfe3357273c07f7ee28e9b"
      (aiPdkCdfSummary aiPdkCdf)
      ()
      ()
      ())
    ("tools/ai/skill" "AI_pdk_db.il" "1950c0672ea8fd76f0f1d5f16ed3d0d0d18c18312678f48f8ddf921a78b60ab9"
      (aiPdkDbAttrs aiPdkPorts aiPdkGeometry aiPdkDatabase)
      ()
      ()
      ())
    ("tools/ai/skill" "AI_pdk_capture.il" "297eda938b5b75d1b6bb631f67604dd9078cbc4255683700dcc7d89d22da7c89"
      (aiPdkIdentity aiPdkCellLess aiPdkDirectory aiPdkDevice aiPdkViewPaths aiPdkCategoryLabel
       aiPdkCategoryLabels aiPdkCategoryRows aiPdkCategories aiPdkCaptureRevision aiPdkCapture aiPdkRead
       aiPdkDrop)
      ((aiPdkCaptureRevision "20260922.ai.pdk.capture.v2"))
      ()
      ())
    ("tools/ai/skill" "AI_pdk_pas.il" "14d378d378837613035f51b9d22c9d2dd7729420d554c3aa7bbe23df42ac8b6e"
      (aiPdkPasRevision aiPdkPasDpt)
      ((aiPdkPasRevision "20261009.ai.pdk.pas.v1"))
      ()
      ())
    ("tools/ai/skill" "AI_pdk_symbol_wire.il" "a742f0f174de3d99cd34965e4998cea39b1f76301e2b33f054d63705b92cc7a0"
      (aiPdkSymbolWireRevision aiPdkSymbolWireProbe)
      ((aiPdkSymbolWireRevision "20261010.ai.pdk.symbolwire.v1"))
      ()
      ())
    ("tools/ai/skill" "AI_window_context.il" "300b307bc764ff29c5efea91ed33f939a3e2a18c9ee8ccd84d3d1178225cbf3d"
      (aiWindowRevision aiWindowTry aiWindowRead aiWindowText aiWindowTitleBytes aiWindowIdentity
       aiWindowDesignLabel aiWindowDiagnostic aiWindowRetire aiWindowGone aiWindowGraphical
       aiWindowCapturable aiWindowSignature aiWindowAdeSession aiWindowObserve aiWindowCaptureState
       aiWindowCapture aiWindowResolveState aiWindowResolve aiWindowStateError aiWindowCv aiWindowBBox
       aiWindowRow aiWindowList aiWindowInspect)
      ((aiWindowRevision "20261020.ai.window.v7"))
      ()
      ())
    ("tools/ai/skill" "AI_selection_context.il" "9162a56d0d83a480691f24809ebef0194cd5a69a17ade1b2b2aacd31b733c84e"
      (aiSelectionRevision aiSelectionText aiSelectionTarget aiSelectionMaster aiSelectionInstance
       aiSelectionNet aiSelectionTerminal aiSelectionItem aiSelectionNetObject aiSelectionShapeName
       aiSelectionShape aiSelectionItemName aiSelectionItemMasterText aiSelectionMatches aiSelectionList
       aiSelectionRaiseWindow aiSelectionWindowTarget aiSelectionMasterMatches aiSelectionHighlightSet
       aiSelectionAddHilight aiSelectionUnionBox aiSelectionObjectBox aiSelectionKey aiSelectionInspect)
      ((aiSelectionRevision "20261021.ai.selection.v2"))
      (aiSelectionVersion)
      ())
    ("tools/ai/skill" "AI_selection_highlight.il" "67872ffe17eb3716ff8c833a42ef3b9cc695142d59574693bbc29c5894ee4a8c"
      (aiSelectionHighlightRevision aiSelectionWindows aiSelectionHighlight)
      ((aiSelectionHighlightRevision "20261021.ai.selection.highlight.v2"))
      (aiSelectionHighlightVersion)
      ())
    ("tools/ai/skill" "AI_entry_context.il" "bb9a25b311d1a31757af0a07fd55839c0d38436beb798a4e7bf182907cc5a4f5"
      (aiEntryDefaultRef aiEntryLibraries aiEntryDesign aiEntryAde aiEntryContext)
      ()
      ()
      ())
    ("tools/ai/skill" "AI_circuit.il" "48f65a749e3553d02bc4e657bf6bb6d9761add81a5bd33084042f4cc55c759b8"
      (aiCircuitRevision aiCircuitNativeCall aiCircuitUpperTaken aiCircuitWindowBox
       aiCircuitPlaceRightHalf aiCircuitRaiseWindow aiCircuitJson aiCircuitBool aiCircuitObject
       aiCircuitError aiCircuitGuiP aiCircuitMode aiCircuitTextP aiCircuitTargetP aiCircuitViewType
       aiCircuitCvMatches aiCircuitSessionMatches aiCircuitSessions aiCircuitMissing aiCircuitOpenApis
       aiCircuitPreflight)
      ((aiCircuitRevision "20260909.ai.circuit.v5"))
      ()
      ())
    ("tools/ai/skill" "AI_circuit_context.il" "d3801b30980a6db9ca7666bd1782d2b4eda5845f3483f2838623158fab78b5d1"
      (aiCircuitContextJson aiCircuitInspect aiCircuitRelease aiCircuitOpen)
      ()
      ()
      ())
    ("tools/ai/skill" "AI_circuit_task.il" "1447e8a2880f5e932f344f87a2581d9c43475d37eb0a14474e41565ac92fabbb"
      (aiCircuitBeginTask aiRcReply aiRcReserve aiRcRequireEntry aiRcRequireSession aiRcRelease)
      ()
      ()
      ())
    ("tools/ai/skill" "AI_circuit_project.il" "50182121929f3c82019a11349169b44ab5bd58f96fa60c4c849b7f3bcbabae60"
      (aiProjectRevision aiProjectSession aiProjectRequire aiProjectAssertClaim aiProjectClaim
       aiProjectTarget aiProjectObserve aiProjectReceipt aiLibraryTechPath aiLibraryMapping
       aiLibraryViewTypes aiLibraryObservation aiLibraryFacts aiLibraryCheck aiLibraryBinding
       aiLibraryRearmHint aiLibraryPrepare aiLibraryReply aiLibraryCreate)
      ((aiProjectRevision "20260911.ai.project.v1"))
      ()
      ())
    ("tools/ai/skill" "AI_circuit_extensions.il" "ff076257f0388e20d7d203fcfb1445f42ae738910480c4fbade17c89db0a7b96"
      (aiCrRegisterExtension aiCrListExtensions aiCrExtension aiCrExtensionValidate aiCrCreateInstance)
      ()
      ()
      ())
    ("tools/ai/skill" "AI_circuit_create_check.il" "ce23062a4e3890a14928f12e3404fe7d0d245cd82b1c2fda67dd84b261736116"
      (aiCreateRevision aiCrEmpty aiCrValueText aiCrRowLess aiCrContains aiCrCenters aiCrCdfRows
       aiCrShapeRows aiCrSafeCdf aiCrParam aiCrMasterSignature aiCrAbsent aiCrTargetFacts
       aiCrInspectTarget aiCrTargetCheck aiCrBoxesOverlap aiCrAdditionBoxCheck aiCrRouteCheckPoints
       aiCrAdditionCheck aiCrWorkPath aiCrDependencies aiCrBodyData aiCrBindingGeometry)
      ((aiCreateRevision "20261022.ai.create.v12"))
      ()
      ())
    ("tools/ai/skill" "AI_circuit_text.il" "ce0914f8c97ee0ec51915927deae23a7a7b161058024d1c64a6744435d911ce9"
      (aiCrTextOverlap aiCrTextCost aiCrTextClear aiCrTextBetter aiCrTextWire aiCrTextPoints
       aiCrTextPlace aiCrTextNote aiCrTextFinish)
      ()
      ()
      ())
    ("tools/ai/skill" "AI_circuit_preview.il" "5008f2a32df6235771f0cacb754084e322e3c00ccecf75fe0ac5953ce665fa63"
      (aiCrExportSvg)
      ()
      ()
      ())
    ("tools/ai/skill" "AI_circuit_create_build.il" "89edb1c560d1480dde0559f923ee1d01ce28a36b8eb4c4a092fa7c8b0e51b8e7"
      (aiCrAppliedParams aiCrSnapshot aiCrReadback aiCrExisting aiCrPrepareCallbacks aiCopyView
       aiCrBoxUnion aiCrRefCenter aiCrLongestSegment aiCrEdgeLabel aiCrStubTerminal aiCrRouteEdge
       aiCrBuild)
      ()
      ()
      ())
    ("tools/ai/skill" "AI_circuit_create.il" "07d9f99a8c9e6b385a46b28e1fca1002a57dfd35401763166c0942c27ab7e137"
      (aiCrErrorText aiCrReply aiCreatePrepare aiCrValidate aiCreateExecute aiCreateInspect
       aiCreateRelease)
      ()
      ()
      ())
    ("tools/ai/skill" "AI_cdf_data.il" "acb323aaf982864bf62ec7b3a87080dd9448a58241d681dfd37d6522ef911dcb"
      (aiCdfRevision aiCdfErrorText aiCdfTyped acdValueLess aiCdfValues aiCdfParamRows aiCdfSnapshot
       aiCdfInspect)
      ((aiCdfRevision "20260910.ai.cdf.v1"))
      ()
      ())
    ("tools/ai/skill" "AI_cdf_transfer.il" "6ef0925ce25d4b79720e5014325012cbac89d8a625f5ea5166a88cab797fe5e2"
      (aiCdfPut aiCdfRead aiCdfDrop)
      ()
      ()
      ())
    ("tools/ai/skill" "AI_test_workspace.il" "7b9e77be8f909a9bcf9ffdeb1049c8d0204f7528b14179d16270ed8512ae2bbb"
      (aiTestWorkspaceLibrary)
      ()
      ()
      ())
    ("tools/ai/skill" "AI_cdf_probe.il" "65a285b300d93387709ad6fd41f840247af728e05c09256e8ca8f8b9c695f2c4"
      (aiCdfProbeRevision aiCdfProbeCheckpoint aiCdfSourceState aiCdfProbeReply aiCdfProbeCapture
       aiCdfProbeRun aiCdfProbe aiCdfProbeGet)
      ((aiCdfProbeRevision "20260924.ai.cdf.probe.v4"))
      ()
      ())
    ("tools/ai/skill" "AI_cdf_callbacks.il" "4b470c4bf0659be47c2dc6ca5265abc16569106ef26ee33fd840ab1a3d7d419d"
      (aiCdfCallbackRevision aiCdfCallbackLiteral aiCdfCallbackParse aiCdfCallbackHook
       aiCdfCallbackInvoke aiCdfCallbackParam aiCdfCallbackEvidence aiCdfCallbackValidate
       aiCdfCallbackEqual aiCdfCallbackApply aiCdfCallbackCreate)
      ((aiCdfCallbackRevision "20261022.ai.cdf.callbacks.v5"))
      ()
      ())
    ("tools/ai/skill" "AI_cdf_update.il" "2ffc4192a18ea77651bb3a58a8cf5b19b55d8d6266a1b5a4c9746cb38e55fa19"
      (aiCdfUpdateCheck aiCdfUpdatePrepare aiCdfUpdateReply aiCdfUpdateApply)
      ()
      ()
      ())
    ("tools/ai/skill" "AI_pdk_cdf_validation.il" "855edc2f89316839b58c129fa3f7b443ad879a5da1d8434fbfb53c09c4b3628c"
      (aiPdkCdfWorkspace aiPdkCdfInspect aiPdkCdfCase)
      ()
      ()
      ())
    ("tools/ai/skill" "AI_simulation_check.il" "f6060f62befd5ab61004ffe4131cc1259c01d586d8c72abd21c84764eac679cf"
      (aiSimulationRevision aiSimFailText aiSimSorted aiSimOptionEqual aiSimConfigRef aiSimSimOptions
       aiSimAssertEqual aiSimSourceSnapshot aiSimFileCheck aiSimSignalResolve aiSimSignalChecks
       aiSimViewNames aiSimViewFirst aiSimViewStep aiSimViewCoverage aiSimSourceReadyP aiSimSources
       aiSimWork aiSimSession aiSimVars aiSimSnapshot aiSimReadback aiSimValidate)
      ((aiSimulationRevision "20261021.ai.simulation.v8"))
      ()
      ())
    ("tools/ai/skill" "AI_simulation_config.il" "c676f7ce3d3f3ae19c05f74dd0aaf647f81c780ac7285550dddc2335fed0276e"
      (aiSimConfigEntry aiSimConfigWalk aiSimConfigInstLess aiSimConfigSource aiSimConfigSummary)
      ()
      ()
      ())
    ("tools/ai/skill" "AI_simulation_dimensions.il" "eb6821c283a353ab99ccc12bb2a2dc1e65d6963e11172f02b7c02bec92dfe3fe"
      (aiSimDimensionPairLess aiSimDimensionCount aiSimExpected aiSimGlobalValues aiSimDimensionSnapshot
       aiSimConfigureDimensions aiSimReadbackDimensions)
      ()
      ()
      ())
    ("tools/ai/skill" "AI_simulation_coordinates.il" "299da5fdce7619363f76d91cef074d9d2134517da4a568a9ae54115e8c5322ea"
      (aiSimCoordinateParam aiSimCoordinateNumber aiSimVerifyCoordinates)
      ()
      ()
      ())
    ("tools/ai/skill" "AI_simulation_setup.il" "9e7e9925cd29e0c32a0a43658c9ce79d57aaac9399bc51d8e7fb6307c23526c3"
      (aiSimReply aiSimConfigure aiSimContext aiSimRememberOutput aiSimPreflight aiSimCreate aiSimModels
       aiSimInspect aiSimRelease)
      ()
      ()
      ())
    ("tools/ai/skill" "AI_simulation_run.il" "fabf98938ecfb22330a4e7b4ab52bdd6c718da437ae4a7640d9fdfa7d2e208d0"
      (aiSimRunReply aiSimCallback aiSimNoActive aiSimIdle aiSimRun aiSimFinished aiSimStatus aiSimStop)
      ()
      ()
      ())
    ("tools/ai/skill" "AI_templates.il" "c95e75951ec83fd81c2dd0fc4d2e1808b82d577f42cf974796ce99e7beb130b4"
      (aiTplGet aiTplQuoted aiTplJson aiTplFields aiTplNet aiTplGlobal aiTplPropName aiTplFigure
       aiTplWrite aiTplRecord aiTplObject aiTplBindingValue aiTplBuiltinLibrary aiTplGraphicRole
       aiTplCaptureAsset aiTplCapture aiTemplatesRevision)
      ((aiTemplatesRevision "20261009.ai.templates.v18"))
      ()
      ())
    ("tools/ai/skill" "AI_template_capture_geometry.il" "d01de64f5e864fa3754c14e7dfdf77ffca7749637e74780abe864d08078b77f4"
      (aiTplLess aiTplResetSavedViews aiTplSavedView aiTplMasterView aiTplDependency aiTplDependencies
       aiTplTextMap aiTplElectricalEvidence aiTplCaptureGeometry)
      ()
      ()
      ())
    ("tools/ai/skill" "AI_template_native_content.il" "c72119ecdf72313b92f5e47c9a5f42f298205ac2f7a71671ac97cdc57b06b2ff"
      (aiTplNativeHash aiTplNativeView aiTplNativeContent)
      ()
      ()
      ())
    ("tools/ai/skill" "AI_circuit_symbol.il" "b09977b25f4a9310372c7933d6b75b78cdc00d63c708b51974a51512cc60da85"
      (aiCircuitSymbolPinBox aiCircuitCreateSymbolBox aiCircuitAnalogPinLabel)
      ()
      ()
      ())
    ("tools/ai/skill" "AI_template_symbol_geometry.il" "c51cfc79bf4a721ea20853b18a2126c83b68894c5f576e49c6ec97d243ecbb0c"
      (aiTsLess aiTsPorts aiTsCheckPorts aiTsSnapshot aiTsBuild aiTsVic)
      ()
      ()
      ())
    ("tools/ai/skill" "AI_template_symbol_draw.il" "fc21b1617c604cb6695b323d75dd3368ba1a5a35735e73e57b9b925306ca34fa"
      (aiTdPreflight aiTdNear aiTdStubLength aiTdContactOnBody aiTdValidateStubs aiTdShape aiTdLabel
       aiTdBuild aiDrawSymbol)
      ()
      ()
      ())
    ("tools/ai/skill" "AI_template_symbol.il" "7621bf7e87849c95abf807bb024c810ae864a4a65883d4a9740c86a0aa930fe5"
      (aiTemplateSymbolRevision aiTsErrorText aiTsLibraryPath aiTsPathWithin aiTsSourceDesignP
       aiTsLibraryGuard aiTsGuardLess aiTsPath aiTsSchematic aiTsAbsent aiTemplateSymbolPreview aiTsReply
       aiTsValidate aiTemplateSymbolCreate aiTemplateSymbolInspect)
      ((aiTemplateSymbolRevision "20261020.ai.template.symbol.v8"))
      ()
      ())
    ("tools/ai/skill" "AI_template_symbol_binding.il" "58bb726eb04600b9d6291b5f8abf11e11e5902bb47d4fa9ada1ccec508e495f4"
      (aiTsBindingData aiTemplateSymbolBinding)
      ()
      ()
      ())
    ("tools/ai/skill" "AI_circuit_config.il" "a237d07e8e3246c14b851e8a3b697ca7f75eefbc5056a0054e263d23278b151d"
      (aiConfigRevision aiConfigRowLess aiConfigDataSnapshot aiConfigRead aiConfigReply aiConfigInterface
       aiConfigInspect aiConfigCreate)
      ((aiConfigRevision "20261022.ai.config.v3"))
      ()
      ())
    ("tools/ai/skill" "AI_maestro_results.il" "d3ccd7cfcd4553509ef9675f1cf73f5e04e7c16f14bf193cdb893baba67498c4"
      (aiResultsRevision aiResultsSession aiResultsValue aiResultsOutput aiResultsCapture aiResultsPage
       aiResultsRelease)
      ((aiResultsRevision "20260910.ai.results.v1"))
      ()
      ())
    ("tools/ai/skill" "AI_maestro_waveform.il" "fd61734075b77e27ab4b4466602ea6a15de7bec41266cdad1a195d202fca3245"
      (aiWaveRevision aiWaveFreeze aiWaveCapture aiWavePage aiWaveRelease)
      ((aiWaveRevision "20260911.ai.waveform.v2"))
      ()
      ())
    ("tools/ai/skill" "AI_maestro_ac.il" "63c77752c92830155105cf129266d367bbd3b7a25a89f5b95e5f9f6285970bf5"
      (aiAcRevision aiAcFinite aiAcFreeze aiAcCapture)
      ((aiAcRevision "20260911.ai.ac.v1"))
      ()
      ())
  ))
  set('aiSharedLoaderVersion "ai.shared.v5.3423d38be853962c53eb089c7b8946cdd85ccd3af5d91d510c4753a7b76a00ab")
)
