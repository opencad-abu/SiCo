; Generated by tools/utility/skill_loader.py --write; edit the manifest/sources.
; Source-only. Per-file contracts retain successful members across retries.
set('aiLoaderVersion nil)
let((entryDirectory)
  entryDirectory=strcat("/" buildString(reverse(cdr(reverse(
    parseString(simplifyFilename(get_filename(piport) t) "/")))) "/"))
  load(strcat(entryDirectory "/../../../scripts/sicoSkillLoader.ils"))
  load(strcat(entryDirectory "/AI_shared.ils"))
  set('aiRoot strcat(SICO_sourceRoot() "/tools/ai"))
  SICO_sourceRequire("assistant" "3eaf3458ccfff918164514f70f69068dc97ccaeade3b00b51118594baf7bcf70" '(
    ("tools/ai/skill" "AI_ipc.il" "a3126f1ee7d2304b9188e34a8424e02eb41c421f41176f5707aeea769fac65f6"
      (aiIpcClearLiveState aiIpcTerminateProcess aiIpcWrite aiIpcRespond aiIpcExecute aiIpcDrainQueue
       aiIpcHandleLine aiIpcDataHandler aiIpcErrHandler aiIpcReset aiIpcRetire aiIpcPostFunc aiStop
       aiIpcSessionAliveP aiIpcActivate aiExitCleanup aiIpcRegisterExitCleanup aiIpcReadyTimeout
       aiIpcStart aiIpcRevision)
      ((aiIpcRevision "20260911.ai.ipc.v13"))
      (aiIpcVersion)
      ())
    ("tools/ai/skill" "AI_live_model.il" "9a759eca591a289e463c82a6933ebb4f6b856d1a725f80e028d0e2805fa20766"
      (aiLiveModelRevision aiLiveModelPair aiLiveModelBoundText aiLiveModelViewKind aiLiveModelIdentity
       aiLiveModelTarget aiLiveModelIdentityPairs aiLiveModelJsonObject aiLiveModelNextSequence
       aiLiveModelTargetPairs aiLiveModelTargetValidP aiLiveModelViewIdentityValidP
       aiLiveModelSessionRunningP aiLiveModelWriteEvent aiLiveModelPostSaveTrigger aiLiveModelScanString
       aiLiveModelScanInteger aiLiveModelForbiddenStatusP aiLiveModelHandleStatus aiLiveModelStart
       aiLiveModelChanged aiLiveModelStop aiLiveModelStatus aiLiveModelReset)
      ((aiLiveModelRevision "20260902.ai.live.v1"))
      (aiLiveModelVersion)
      ())
    ("tools/ai/skill" "AI_launcher.il" "4988c77c30c1d6a856d3198e10337de7f6773f98f324f8bbff6bc87bba653515"
      (aiShellQuote aiEnvValue aiProductEnvironment aiCanonicalPath aiPythonVersionOK aiProductionPythonP
       aiControllerReadyDelay aiPythonExecutable aiPythonEntry aiControllerCommand aiStartAgent aiStart
       aiLaunchFormCB aiCreateLaunchForm cadDisplayAiAssistant aiLauncherRevision)
      ((aiLauncherRevision "20261020.sico.launcher.v21"))
      (aiLauncherVersion)
      ())
    ("tools/ai/skill" "AI_flow_command.il" "e8b01ef38f5a86dd48c86c248b580a64bfc4059cd95678187e8e2b307df44c0b"
      (aiWorkflowEnv aiWorkflowTempEnvironment aiWorkflowShellQuote aiWorkflowJsonEscape aiWorkflowError
       aiWorkflowSafeTextP aiWorkflowInputPath aiWorkflowToolsRoot aiWorkflowPython aiWorkflowExecutableP
       aiWorkflowEntry aiWorkflowCommandName aiWorkflowLibraryPath aiWorkflowStopValues
       aiWorkflowValidate)
      ()
      (aiWorkflowVersion)
      ())
    ("tools/ai/skill" "AI_flows.il" "1f137e292800019d2b2fcb089999d2d1cd01c4809d7f37e8ff7eda5055190c24"
      (aiWorkflowNextId aiWorkflowCreateRuntimeDir aiWorkflowWriteLauncher aiWorkflowLogLimit
       aiWorkflowLogMarker aiWorkflowAppendLog aiWorkflowCleanupJobArtifacts aiWorkflowJobCount
       aiWorkflowEvictOldestTerminal aiWorkflowReserveJobSlot aiWorkflowCommand aiWorkflowLaunch
       aiWorkflowDataHandler aiWorkflowErrHandler aiWorkflowPostFunc aiWorkflowStart
       aiWorkflowAnalyzeDspf aiWorkflowStatus aiWorkflowTerminate aiWorkflowExitCleanup
       aiWorkflowRegisterExitCleanup aiWorkflowRevision)
      ((aiWorkflowRevision "20261020.sico.flow.v7"))
      (aiWorkflowVersion)
      ())
    ("tools/ai/skill" "AI_maestro.il" "51c6fa6704fdb40145b0a2923a82476c19aec1aac935692fd636213f3819cf13"
      (aiMaestroMissingCapabilities aiMaestroViewSession aiMaestroApplySpec aiMaestroCreate
       aiMaestroActiveJobForViewP aiMaestroNewJob aiMaestroReserveJobSlot aiMaestroFindJobBySession
       aiMaestroQueueFinish aiMaestroChecksFailedP aiMaestroProgressCompleteP aiMaestroFinishJob
       aiMaestroRunCallback aiMaestroFinishPending aiMaestroJobJson aiMaestroRun aiMaestroStatus
       aiMaestroStop aiMaestroCleanup aiMaestroRegisterExitCleanup aiMaestroRevision)
      ((aiMaestroRevision "20260908.ai.maestro.v2"))
      (aiMaestroVersion)
      ())
    ("tools/ai/skill" "AI_maestro_validate.il" "07cda88f5a8fe934a77d9189a5f27335dba5e9f17383253db6d0264b64bb91f1"
      (aiMaestroBoundText aiMaestroJsonString aiMaestroValueJson aiMaestroListJson aiMaestroError
       aiMaestroTextP aiMaestroBooleanP aiMaestroDataP aiMaestroPairListP aiMaestroStringListP
       aiMaestroVarListP aiMaestroFileP aiMaestroValidateCreate)
      ()
      (aiMaestroValidationVersion)
      ())
    ("tools/ai/skill" "AI_circuit_rc.il" "9d1f92b99c0912002538b97d745156a3a4e7135feca9a99254c2b93ad50879ac"
      (aiRcGeometrySnapshot aiRcAnchor aiRcProperty aiRcWire aiRcVerify aiRcValidateSaved aiRcCreate)
      ()
      ()
      ())
    ("tools/ai/skill" "AI_circuit_rc_maestro.il" "06777c0886a3fe02ef3feab6f968fd7d79bbda92bed4e0b465ea73025d439fac"
      (aiRcSetupSnapshot aiRcMaestro)
      ()
      ()
      ())
    ("tools/ai/skill" "AI_circuit_rc_run.il" "5f0024fc7a523b0b0b653bfbf78b77d1f604a4b041587e1c625cddf53e58ed7c"
      (aiRcRunJson aiRcRunCallback aiRcRun aiRcStatus aiRcResults aiRcStop)
      ()
      ()
      ())
    ("tools/ai/skill" "AI_circuit_gate_devices.il" "83763c5428998a1f14cc1ee6a5dc1390701aa96907fbab219f333eb71ed9444c"
      (aiGateMos aiGateParams aiGatePoint aiGateWire aiGateSchematic aiGateSymbol)
      ()
      ()
      ())
    ("tools/ai/skill" "AI_circuit_gate_verify.il" "e27eab725dc9fac5143c32d5b87a70e42eb0e6664315ae822e50b147edbad2ea"
      (aiGateVerifyPorts aiGateVerifySchematic aiGateSnapshot aiGateValidate)
      ()
      ()
      ())
    ("tools/ai/skill" "AI_circuit_gate.il" "374c4bac6c65e7da2462243e3b5bc0bd4d36f53b13903a1b8d25327d215efea2"
      (aiGateReply aiGateInspect aiGateBuildView aiGateCreate)
      ()
      ()
      ())
    ("tools/ai/skill" "AI_circuit_opamp_contract.il" "447db898652a72d9666dd4545550620f1622dc884b20173cea6987396436b5e3"
      (aiOpampReferenceContract)
      ()
      ()
      ())
    ("tools/ai/skill" "AI_circuit_opamp.il" "b9ffa4f49f6c921b948f2c659f5f53eb75fb85e35de0fe6cba4a9231e8a93cbe"
      (aiOpampRevision aiOpampSetupSnapshot aiOpampDesignSnapshot aiOpampReply aiOpampSession
       aiOpampValidate aiOpampInspect aiOpampCreate)
      ((aiOpampRevision "20260910.ai.opamp.v3"))
      ()
      ())
    ("tools/ai/skill" "AI_circuit_opamp_run.il" "d1c704199289a506a49c16ee0c6e86f3e3e79c66a778ac418a0a94dadd9cfd10"
      (aiOpampRunReply aiOpampCallback aiOpampIdle aiOpampNoActive aiOpampRun aiOpampStatus aiOpampStop
       aiOpampRelease)
      ()
      ()
      ())
    ("tools/ai/skill" "AI_circuit_opamp_results.il" "254aef59b0cfcb3088186f82a707f21f16daeeb8e5508ec8e6f55af03cbc3c11"
      (aiOpampMeasurements aiOpampResults)
      ()
      ()
      ())
    ("tools/ai/skill" "AI_circuit_rebuild_source.il" "aebdea9290db5de255d688dce648a16308fa5cf92354b8c5b1546d251eb2e734"
      (aiRebuildRevision aiRebuildConnections aiRebuildSource aiRebuildSources aiRebuildPaths
       aiRebuildMasters aiRebuildSourceContract)
      ((aiRebuildRevision "20260909.ai.rebuild.v2"))
      ()
      ())
    ("tools/ai/skill" "AI_circuit_rebuild_devices.il" "047b59eb7ebc56890cbc19915489d1de59ef722c888645667161c21547ee5a30"
      (aiRebuildInst aiRebuildPin aiRebuildStub aiRebuildDut aiRebuildTb aiRebuildSymbol)
      ()
      ()
      ())
    ("tools/ai/skill" "AI_circuit_rebuild.il" "16eac5d4fd2c679b9eb4ce2cf0d954e5b1d4728bd76ff64bbc71e067a53ed17e"
      (aiRebuildReply aiRebuildPreview aiRebuildCheck aiRebuildBuild aiRebuildValidate aiRebuildCreate
       aiRebuildInspect)
      ()
      ()
      ())
    ("tools/ai/skill" "AI_circuit_rebuild_maestro.il" "b98bf83a257d7df4c87358485467edae9080b5f9a9dd78d23b31906f4c5ee85e"
      (aiRebuildBindTests aiRebuildSimulationValidate aiRebuildMaestro aiRebuildRun)
      ()
      ()
      ())
    ("tools/ai/skill" "AI_circuit_matrix.il" "2f04f097380ebd3c83d7c3ee01101c0afacb33505128b579d1545657cdd897ef"
      (aiMatrixRevision aiMatrixSnapshot aiMatrixValues aiMatrixValidate aiMatrixConfigure aiMatrixCreate
       aiMatrixInspect aiMatrixRun)
      ((aiMatrixRevision "20260910.ai.matrix.v1"))
      ()
      ())
    ("tools/ai/skill" "AI_circuit_matrix_results.il" "9b9765cf5172b04ed945517a28f2070c363133217c60d1499cd23cbf4d6c1028"
      (aiMatrixParam aiMatrixMatch aiMatrixScalar aiMatrixResults)
      ()
      ()
      ())
  ))
  set('aiLoaderVersion aiLoaderRevision())
)
