; Fixture-only passive RC: stimulus left, capacitor load right, labelled stubs,
; two physical basic/gnd instances. No inherited connection or global wire label.
procedure(pairFixtureStub(pfsCv pfsInst pfsPin pfsNet pfsDx)
  let((pfsP pfsQ)
    pfsP=aiRcAnchor(pfsInst pfsPin) pfsQ=list(xCoord(pfsP)+pfsDx yCoord(pfsP))
    aiRcWire(pfsCv list(pfsP pfsQ) pfsNet)))
procedure(pairFixtureCreate()
  prog((pfcCv pfcMaster pfcSource pfcR pfcC pfcGround pfcPin pfcWindow)
    when(ddGetObj("genericWork" "paired_rc" "schematic") error("fixture target exists"))
    pfcCv=dbOpenCellViewByType("genericWork" "paired_rc" "schematic" "schematic" "a")
    pfcMaster=dbOpenCellViewByType("analogLib" "vpulse" "symbol" "" "r")
    pfcSource=schCreateInst(pfcCv pfcMaster "V1" -3:1 "R0") dbClose(pfcMaster)
    foreach(pfcProp list(list("v1" "0") list("v2" "1") list("vdc" "1")
      list("td" "1u") list("tr" "1n") list("tf" "1n") list("pw" "20u") list("per" "40u"))
      aiRcProperty(pfcSource car(pfcProp) cadr(pfcProp)))
    pairFixtureStub(pfcCv pfcSource "PLUS" "IN" 0.5)
    pfcMaster=dbOpenCellViewByType("analogLib" "res" "symbol" "" "r")
    pfcR=schCreateInst(pfcCv pfcMaster "R1" 0:1 "R90") dbClose(pfcMaster)
    aiRcProperty(pfcR "r" "RVAL")
    pairFixtureStub(pfcCv pfcR "PLUS" "IN" -0.5)
    pairFixtureStub(pfcCv pfcR "MINUS" "OUT" 0.5)
    pfcMaster=dbOpenCellViewByType("analogLib" "cap" "symbol" "" "r")
    pfcC=schCreateInst(pfcCv pfcMaster "C1" 4:1 "R0") dbClose(pfcMaster)
    aiRcProperty(pfcC "c" "1n") pairFixtureStub(pfcCv pfcC "PLUS" "OUT" 0.5)
    pfcMaster=dbOpenCellViewByType("basic" "gnd" "symbol" "" "r")
    foreach(pfcDevice list(pfcSource pfcC)
      pfcPin=aiRcAnchor(pfcDevice "MINUS")
      pfcGround=schCreateInst(pfcCv pfcMaster strcat("G_" pfcDevice~>name)
        list(xCoord(pfcPin) yCoord(pfcPin)-0.5) "R0")
      aiRcWire(pfcCv list(pfcPin aiRcAnchor(pfcGround "gnd!"))))
    dbClose(pfcMaster)
    unless(equal(schCheck(pfcCv) list(0 0)) error("pair fixture check failed"))
    unless(length(setof(pfcI pfcCv~>instances and(pfcI~>libName=="basic" pfcI~>cellName=="gnd")))==2
      error("physical ground fixture missing"))
    when(setof(pfcSh pfcCv~>shapes pfcSh~>theLabel=="gnd!") error("global ground label in fixture"))
    dbSave(pfcCv) dbClose(pfcCv)
    pfcWindow=deOpenCellView("genericWork" "paired_rc" "schematic" "schematic" nil "r")
    hiZoomIn(pfcWindow geGetWindowCellView(pfcWindow)~>bBox)
    return(t)))
