; Test-only RLC lowpass H=1/(1+sRC+s²LC), used as an explicitly declared loop model.
; Source left, series R/L center, shunt capacitor right, physical basic/gnd instances.
procedure(responseFixtureCreate()
  prog((rfcCv rfcMaster rfcSource rfcR rfcL rfcC rfcGround rfcPin rfcWindow rfcProp rfcDevice)
    when(ddGetObj("genericWork" "response_rlc" "schematic") error("fixture target exists"))
    rfcCv=dbOpenCellViewByType("genericWork" "response_rlc" "schematic" "schematic" "a")
    rfcMaster=dbOpenCellViewByType("analogLib" "vsin" "symbol" "" "r")
    rfcSource=schCreateInst(rfcCv rfcMaster "V1" -3:1 "R0") dbClose(rfcMaster)
    foreach(rfcProp list(list("acm" "2") list("acp" "30") list("vdc" "0"))
      aiRcProperty(rfcSource car(rfcProp) cadr(rfcProp)))
    pairFixtureStub(rfcCv rfcSource "PLUS" "IN" 0.5)
    rfcMaster=dbOpenCellViewByType("analogLib" "res" "symbol" "" "r")
    rfcR=schCreateInst(rfcCv rfcMaster "R1" 0:1 "R90") dbClose(rfcMaster)
    aiRcProperty(rfcR "r" "RVAL")
    pairFixtureStub(rfcCv rfcR "PLUS" "IN" -0.5)
    pairFixtureStub(rfcCv rfcR "MINUS" "MID" 0.5)
    rfcMaster=dbOpenCellViewByType("analogLib" "ind" "symbol" "" "r")
    rfcL=schCreateInst(rfcCv rfcMaster "L1" 3:1 "R90") dbClose(rfcMaster)
    aiRcProperty(rfcL "l" "10m")
    pairFixtureStub(rfcCv rfcL "PLUS" "MID" -0.5)
    pairFixtureStub(rfcCv rfcL "MINUS" "OUT" 0.5)
    rfcMaster=dbOpenCellViewByType("analogLib" "cap" "symbol" "" "r")
    rfcC=schCreateInst(rfcCv rfcMaster "C1" 6:1 "R0") dbClose(rfcMaster)
    aiRcProperty(rfcC "c" "1n") pairFixtureStub(rfcCv rfcC "PLUS" "OUT" 0.5)
    rfcMaster=dbOpenCellViewByType("basic" "gnd" "symbol" "" "r")
    foreach(rfcDevice list(rfcSource rfcC)
      rfcPin=aiRcAnchor(rfcDevice "MINUS")
      rfcGround=schCreateInst(rfcCv rfcMaster strcat("G_" rfcDevice~>name)
        list(xCoord(rfcPin) yCoord(rfcPin)-0.5) "R0")
      aiRcWire(rfcCv list(rfcPin aiRcAnchor(rfcGround "gnd!"))))
    dbClose(rfcMaster)
    unless(equal(schCheck(rfcCv) list(0 0)) error("RLC fixture check failed"))
    unless(length(setof(rfcI rfcCv~>instances and(rfcI~>libName=="basic" rfcI~>cellName=="gnd")))==2
      error("physical ground fixture missing"))
    when(setof(rfcSh rfcCv~>shapes rfcSh~>theLabel=="gnd!") error("global label in fixture"))
    dbSave(rfcCv) dbClose(rfcCv)
    rfcWindow=deOpenCellView("genericWork" "response_rlc" "schematic" "schematic" nil "r")
    hiZoomIn(rfcWindow geGetWindowCellView(rfcWindow)~>bBox)
    return(t)))
