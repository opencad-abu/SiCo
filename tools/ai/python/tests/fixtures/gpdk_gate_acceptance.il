; Acceptance harness only: two generated testbenches, exact history/RDB samples.
procedure(gateAcceptanceSetup(lib cell root @optional (designView "schematic"))
  prog((gs gw)
    unless(ddGetObj(lib cell "schematic") error("testbench missing"))
    when(ddGetObj(lib cell "maestro") error("setup exists"))
    gs=maeOpenSetup(lib cell "maestro" ?application "Assembler" ?mode "a")
    unless(gs error("setup failed"))
    unless(maeCreateTest("GATE" ?lib lib ?cell cell ?view designView ?simulator "spectre" ?session gs) error("test failed"))
    unless(maeSetEnvOption("GATE" ?options list(list("modelFiles" list(list(
      strcat(root "/models/spectre/gpdk045.scs") "tt")))) ?session gs) error("model config failed"))
    unless(maeSetAnalysis("GATE" "tran" ?enable t ?options list(list("stop" "4n") list("maxstep" "2p") list("errpreset" "conservative")) ?session gs) error("tran config failed"))
    foreach(net if(rexMatchp("nand" cell) list("A" "B" "Y") list("A" "Y"))
      unless(maeAddOutput(net "GATE" ?outputType "net" ?signalName strcat("/" net) ?plot t ?save t ?session gs) error("wave output failed"))
      for(idx 0 3
        unless(maeAddOutput(sprintf(nil "%s%d" net idx) "GATE" ?outputType "point"
          ?expr sprintf(nil "value(VT(\"/%s\") %.12g)" net (idx+0.5)*1e-9) ?plot t ?save t ?session gs) error("scalar output failed"))))
    unless(maeSaveSetup(?session gs) error("save failed"))
    unless(maeCloseSession(?session gs) error("bootstrap close failed"))
    gw=deOpenCellView(lib cell "maestro" "maestro" nil "a")
    gs=axlGetWindowSession(gw)
    unless(gs error("GUI handoff failed"))
    maeSaveSetup(?session gs)
    return(gs)))
unless(boundp('gateAcceptanceDone) gateAcceptanceDone=makeTable("gateDone" nil))
procedure(gateAcceptanceCallback(gs runId) gateAcceptanceDone[gs]=runId t)
procedure(gateAcceptanceResults(gs history)
  let((rdb rows)
    unless(gateAcceptanceDone[gs] error("not completed"))
    unless(equal(axlGetRunStatus(gs ?historyName history) list(1 1)) error("incomplete point"))
    rdb=maeReadResDB(?session gs ?historyName history)
    unless(length(rdb->points())==1 error("unexpected point count"))
    foreach(pt rdb->points()
      foreach(out pt->outputs(?type 'expr)
        rows=cons(list(out->name out->value out->cornerName out->testName pt->id) rows)))
    aiCircuitObject(list(list("history" history) list("rows" rows)
      list("errors" maeGetSimulationMessages(?session gs ?msgType "ERROR"))))))
