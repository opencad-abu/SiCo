; Project-free passive Config fixture: explicit scalar pins and physical basic/gnd.
procedure(configFixtureStub(cfsCv cfsInst cfsPin cfsNet cfsDx)
  let((cfsP cfsQ)
    cfsP=aiRcAnchor(cfsInst cfsPin) cfsQ=list(xCoord(cfsP)+cfsDx yCoord(cfsP))
    aiRcWire(cfsCv list(cfsP cfsQ) cfsNet)))
procedure(configFixtureCreate()
  prog((cffCv cffMaster cffInst cffPin cffSym cffGround cffSource cffLoad)
    foreach(cffView list("schematic" "schematic_alt")
      cffCv=dbOpenCellViewByType("genericWork" "resblock" cffView "schematic" "w")
      cffMaster=dbOpenCellViewByType("analogLib" "res" "symbol" "" "r")
      cffInst=schCreateInst(cffCv cffMaster "R1" 0:0 "R90") dbClose(cffMaster)
      aiRcProperty(cffInst "r" if(cffView=="schematic" "1K" "3K"))
      cffMaster=dbOpenCellViewByType("basic" "iopin" "symbol" "" "r")
      schCreatePin(cffCv cffMaster "P" "inputOutput" nil -1:0 "R0")
      schCreatePin(cffCv cffMaster "N" "inputOutput" nil 2:0 "R0") dbClose(cffMaster)
      aiRcWire(cffCv list(-1:0 aiRcAnchor(cffInst "PLUS")))
      aiRcWire(cffCv list(2:0 aiRcAnchor(cffInst "MINUS")))
      unless(equal(schCheck(cffCv) list(0 0)) error("fixture block check")) dbSave(cffCv) dbClose(cffCv))
    cffCv=dbOpenCellViewByType("genericWork" "resblock" "symbol" "schematicSymbol" "w")
    cffMaster=dbOpenCellViewByType("basic" "sympin" "symbolNN" "" "r")
    schCreateSymbolShape(cffCv "rectangle" "outline" list(0:0 1:1))
    foreach(cffPort list(list("P" -0.25:0.5 0:0.5) list("N" 1.25:0.5 1:0.5))
      schCreateSymbolPin(cffCv cffMaster car(cffPort) "inputOutput" cadr(cffPort) "R0")
      schCreateSymbolShape(cffCv "line" "outline" list(cadr(cffPort) caddr(cffPort)))
      schCreateSymbolLabel(cffCv cadr(cffPort) "analog pin annotate" sprintf(nil "cdsTerm(%L)" car(cffPort))
        "lowerCenter" "R0" "stick" 0.125 "ILLabel"))
    schCreateSymbolLabel(cffCv 0.5:0.5 "symbol shape" "R block" "centerCenter" "R0" "fixed" 0.125 "normalLabel")
    schCreateSymbolLabel(cffCv 0:1.125 "instance label" "[@instanceName]" "lowerLeft" "R0" "fixed" 0.125 "NLPLabel")
    schCreateInstBox(cffCv list(-0.25:0 1.25:1)) dbClose(cffMaster) dbSave(cffCv) dbClose(cffCv)
    cffCv=dbOpenCellViewByType("genericWork" "config_tb" "schematic" "schematic" "w")
    cffMaster=dbOpenCellViewByType("genericWork" "resblock" "symbol" "" "r")
    cffInst=schCreateInst(cffCv cffMaster "I_resblock_0" 4:1 "R0") dbClose(cffMaster)
    configFixtureStub(cffCv cffInst "P" "IN" -0.5)
    configFixtureStub(cffCv cffInst "N" "OUT" 0.5)
    cffMaster=dbOpenCellViewByType("analogLib" "vdc" "symbol" "" "r")
    cffSource=schCreateInst(cffCv cffMaster "VSUP" 0:1 "R0") dbClose(cffMaster)
    aiRcProperty(cffSource "vdc" "1") configFixtureStub(cffCv cffSource "PLUS" "IN" 0.5)
    cffMaster=dbOpenCellViewByType("analogLib" "res" "symbol" "" "r")
    cffLoad=schCreateInst(cffCv cffMaster "RL" 8:1 "R0") dbClose(cffMaster)
    aiRcProperty(cffLoad "r" "RLOAD") configFixtureStub(cffCv cffLoad "PLUS" "OUT" 0.5)
    cffMaster=dbOpenCellViewByType("basic" "gnd" "symbol" "" "r")
    foreach(cffDev list(cffSource cffLoad)
      cffPin=aiRcAnchor(cffDev "MINUS")
      cffGround=schCreateInst(cffCv cffMaster strcat("G_" cffDev~>name) list(xCoord(cffPin) yCoord(cffPin)-0.5) "R0")
      aiRcWire(cffCv list(cffPin aiRcAnchor(cffGround "gnd!"))))
    dbClose(cffMaster)
    unless(equal(schCheck(cffCv) list(0 0)) error("fixture TB check")) dbSave(cffCv) dbClose(cffCv)
    return(t)))
