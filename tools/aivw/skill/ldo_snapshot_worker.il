; Controller-owned saved schematic/symbol readback.  Only named read-mode
; inspectors are loaded; no UI, AI session, write callback or publisher runs.
procedure(aivwLdoWriteInspection(directory label value)
  let((stream)
    stream=outfile(strcat(directory "/" label ".json") "w")
    unless(stream error("Cannot open controller-owned inspection output"))
    fprintf(stream "%s\n" value)
    close(stream)
  )
)

let((sourceRoot outputRoot libraryName cellName)
  sourceRoot=getShellEnvVar("AIVW_LDO_AI_ROOT")
  outputRoot=getShellEnvVar("AIVW_LDO_SNAPSHOT_OUTPUT")
  libraryName=getShellEnvVar("AIVW_LDO_LIBRARY")
  cellName=getShellEnvVar("AIVW_LDO_CELL")
  unless(and(sourceRoot outputRoot libraryName cellName) exit(2))
  load(strcat(sourceRoot "/skill/AI_protocol.il"))
  load(strcat(sourceRoot "/skill/AI_inspect.il"))
  foreach(phase list("before" "after")
    aivwLdoWriteInspection(outputRoot strcat("library-" phase)
      aiInspectLibrary(libraryName))
    aivwLdoWriteInspection(outputRoot strcat("schematic-" phase)
      aiInspectSchematic(libraryName cellName "schematic" "schematic" 200 nil))
    aivwLdoWriteInspection(outputRoot strcat("symbol-" phase)
      aiInspectSymbolPorts(libraryName cellName "symbol" "schematicSymbol" 200))
  )
)
exit(0)
