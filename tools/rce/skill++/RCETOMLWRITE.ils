; Serialize validated run configuration sections to TOML. SKILL++ lexical scope.

procedure(rceWriteRunToml(outFile form runDir cdslib)
  let(()
    SICO_tomlWriteSection(outFile "run")
    SICO_tomlWriteString(outFile "run_dir" runDir)
    SICO_tomlWriteString(outFile "cds_lib" cdslib)
    SICO_tomlWriteString(outFile "run_type" form~>runType~>value)
    SICO_tomlWriteString(outFile "queue_name" form~>queueName~>value)
    SICO_tomlWriteString(
      outFile "server_name" SICO_lsfSelectedHost(form~>srvName~>value))
  )
)

procedure(rceWriteInputTypeToml(outFile inputType)
  let(()
    SICO_tomlWriteSection(outFile "input")
    SICO_tomlWriteString(outFile "type" inputType)
  )
)

procedure(rceWriteSchematicToml(outFile schlib schcell schview cdlIncludeFile)
  let(()
    SICO_tomlWriteSection(outFile "input.schematic")
    SICO_tomlWriteString(outFile "lib" schlib)
    SICO_tomlWriteString(outFile "cell" schcell)
    SICO_tomlWriteString(outFile "view" schview)
    SICO_tomlWriteString(outFile "cdl_header_file" cdlIncludeFile)
  )
)

procedure(rceWriteLayoutToml(outFile laylib laycell layview layerMap)
  let(()
    SICO_tomlWriteSection(outFile "input.layout")
    SICO_tomlWriteString(outFile "lib" laylib)
    SICO_tomlWriteString(outFile "cell" laycell)
    SICO_tomlWriteString(outFile "view" layview)
    SICO_tomlWriteString(outFile "layer_map" layerMap)
  )
)

procedure(rceWriteCdlToml(outFile form cdl cdlcell)
  let(()
    SICO_tomlWriteSection(outFile "input.cdl")
    SICO_tomlWriteString(outFile "run_directory"
      if(rceNeedsCdlRunDirectory(form) then
        SICO_absolutePath(form~>cdlRunDirectory~>value) else ""))
    SICO_tomlWriteString(outFile "file" cdl)
    SICO_tomlWriteString(outFile "cell" cdlcell)
  )
)

procedure(rceWriteGdsToml(outFile gds gdscell)
  let(()
    SICO_tomlWriteSection(outFile "input.gds")
    SICO_tomlWriteString(outFile "file" gds)
    SICO_tomlWriteString(outFile "cell" gdscell)
  )
)

procedure(rceWriteSvdbToml(outFile svdb svdbcell)
  let(()
    SICO_tomlWriteSection(outFile "input.svdb")
    SICO_tomlWriteString(outFile "dir" svdb)
    SICO_tomlWriteString(outFile "cell" svdbcell)
  )
)

procedure(rceWriteCciToml(outFile cci ccicell)
  let(()
    SICO_tomlWriteSection(outFile "input.cci")
    SICO_tomlWriteString(outFile "dir" cci)
    SICO_tomlWriteString(outFile "cell" ccicell)
  )
)

procedure(rceWriteLvsToml(outFile form runsetFile hcellFile)
  let((lvsVirtualConn)
    SICO_tomlWriteSection(outFile "lvs")
    SICO_tomlWriteString(outFile "tool" form~>lvsTool~>value)
    SICO_tomlWriteString(outFile "runset_name" form~>lvsRunsetName~>value)
    SICO_tomlWriteString(outFile "runset_file" runsetFile)
    SICO_tomlWriteBool(outFile "hcell_enable" form~>lvsHcellBtn~>value)
    SICO_tomlWriteString(outFile "hcell_file" hcellFile)
    SICO_tomlWriteBool(outFile "ignore_error" form~>lvsIgnoreError~>value)
    SICO_tomlWriteBool(outFile "case_sensitive" form~>lvsCaseBtn~>value)
    SICO_tomlWriteString(outFile "recognize_gates" form~>lvsRecognizeGates~>value)
    SICO_tomlWriteBool(outFile "custom_svrf_enable" form~>customSvrfEnable~>value)
    SICO_tomlWriteString(outFile "custom_svrf_command"
                        or(form~>customSvrfCommand~>value ""))
    lvsVirtualConn=form~>lvsVirtualConn~>value
    SICO_tomlWriteBool(outFile "virtual_connect_enable" car(lvsVirtualConn))
    SICO_tomlWriteBool(outFile "virtual_connect_name_enable" cadr(lvsVirtualConn))
    ; Retain a canonical legacy value for older command generators without
    ; depending on the session's list-printing representation.
    SICO_tomlWriteString(outFile "virtual_connect"
      sprintf(nil "(%s %s)"
        if(car(lvsVirtualConn) then "t" else "nil")
        if(cadr(lvsVirtualConn) then "t" else "nil")))
    SICO_tomlWriteString(outFile "virtual_connect_names" form~>lvsVirtualConnName~>value)
  )
)

procedure(rceWriteExtractToml(outFile form techDir processCorner processCorners cornerTemperatures)
  let(()
    SICO_tomlWriteSection(outFile "extract")
    SICO_tomlWriteString(outFile "tool" form~>extTool~>value)
    SICO_tomlWriteString(outFile "tech_name" form~>rcTechDirName~>value)
    SICO_tomlWriteString(outFile "tech_dir" techDir)
    SICO_tomlWriteString(outFile "corner_scope" form~>cornerType~>value)
    SICO_tomlWriteString(outFile "corner" processCorner)
    SICO_tomlWriteStringList(outFile "corners" processCorners)
    SICO_tomlWriteString(outFile "temperature" car(cornerTemperatures))
    SICO_tomlWriteStringList(outFile "corner_temperatures" cornerTemperatures)
    SICO_tomlWriteString(outFile "rc_type" form~>rcType~>value)
    SICO_tomlWriteBool(outFile "remove_floating_nets"
                       form~>rmFloatNetsBtn~>value)
    SICO_tomlWriteString(outFile "top_cell_source"
                         lowerCase(form~>topCellSource~>value))
    SICO_tomlWriteString(outFile "name_source"
                         lowerCase(form~>nameSource~>value))
    SICO_tomlWriteString(outFile "output_type" form~>outType~>value)
    SICO_tomlWriteBool(outFile "start_rve"
                       and(form~>startRve
                            RCE_calibrePexToolP(form~>extTool~>value)
                            form~>startRve~>value))
  )
)

procedure(rceWriteViewToml(outFile form nativeView viewTarget viewDeviceMap viewLayerMap)
  let(()
    SICO_tomlWriteSection(outFile "extract.view")
    SICO_tomlWriteString(outFile "kind"
                         if(nativeView then rceNativeViewKindValue(form) else ""))
    SICO_tomlWriteString(outFile "library"
                         if(nativeView then car(viewTarget) else ""))
    SICO_tomlWriteString(outFile "cell"
                         if(nativeView then cadr(viewTarget) else ""))
    SICO_tomlWriteString(outFile "name"
                         if(nativeView then caddr(viewTarget) else ""))
    SICO_tomlWriteString(outFile "layout_view"
                         or(rceNativeViewLayoutView(form) ""))
    SICO_tomlWriteString(outFile "cellmap_file"
                         if(and(nativeView
                                RCE_calibrePexToolP(form~>extTool~>value))
                           then viewDeviceMap else ""))
    SICO_tomlWriteString(outFile "device_mapping_file"
                         if(and(nativeView form~>extTool~>value=="StarRC")
                           then viewDeviceMap else ""))
    SICO_tomlWriteString(outFile "layer_mapping_file"
                         if(and(nativeView form~>extTool~>value=="StarRC")
                           then viewLayerMap else ""))
  )
)

procedure(rceWriteReductionToml(outFile form)
  let((reductionSelection reductionCanonical)
    reductionSelection=rceReductionAbsolutePath(
      form~>reductionSelectionFile~>value)
    reductionCanonical=rceReductionAbsolutePath(
      form~>reductionCanonicalDeviceFile~>value)
    SICO_tomlWriteSection(outFile "reduction")
    SICO_tomlWriteBool(outFile "enabled" form~>reductionEnable~>value)
    SICO_tomlWriteString(outFile "mode" form~>reductionMode~>value)
    SICO_tomlWriteString(outFile "output_tag" form~>reductionOutputTag~>value)
    SICO_tomlWriteString(outFile "cpus" form~>extCpu~>value)
    SICO_tomlWriteString(outFile "control" form~>reductionControl~>value)
    SICO_tomlWriteString(outFile "delay_rel" form~>reductionDelayRel~>value)
    SICO_tomlWriteString(outFile "delay_abs" form~>reductionDelayAbs~>value)
    SICO_tomlWriteString(outFile "frequency" form~>reductionFrequency~>value)
    SICO_tomlWriteString(outFile "temperature"
                         form~>reductionTemperature~>value)
    SICO_tomlWriteString(outFile "ground" form~>reductionGround~>value)
    SICO_tomlWriteBool(outFile "reduce_negative"
                       form~>reductionNegative~>value)
    SICO_tomlWriteString(outFile "selection_file" reductionSelection)
    SICO_tomlWriteString(outFile "canonical_device_file" reductionCanonical)
  )
)

procedure(rceWriteRuntimeToml(outFile form)
  let(()
    SICO_tomlWriteSection(outFile "runtime")
    SICO_tomlWriteString(outFile "lvs_cpus" form~>lvsCpu~>value)
    SICO_tomlWriteString(outFile "ext_cpus" form~>extCpu~>value)
  )
)

procedure(rceWriteSelectionToml(outFile form netsFile cellsFile)
  let(()
    SICO_tomlWriteSection(outFile "selection")
    SICO_tomlWriteBool(outFile "net_enable" form~>netSelBtn~>value)
    SICO_tomlWriteString(outFile "net_type" form~>netSelChoices~>value)
    SICO_tomlWriteString(outFile "nets" netsFile)
    SICO_tomlWriteBool(outFile "cell_enable" form~>cellSelBtn~>value)
    SICO_tomlWriteString(outFile "cell_type" "Block Cells")
    SICO_tomlWriteString(outFile "cells" cellsFile)
  )
)

procedure(rceWriteFilterToml(outFile form)
  let(()
    SICO_tomlWriteSection(outFile "filter")
    SICO_tomlWriteString(outFile "cap_percentage" if(form~>relFilterCapBtn~>value then form~>relFilterCapValue~>value else ""))
    SICO_tomlWriteString(outFile "cap_value" if(form~>absFilterCapBtn~>value then form~>absFilterCapValue~>value else ""))
    SICO_tomlWriteString(outFile "res_value" if(form~>absFilterResBtn~>value then form~>absFilterResValue~>value else ""))
  )
)

procedure(rceWriteNetlistToml(outFile form outPath createView pinControlFile)
  let(()
    SICO_tomlWriteSection(outFile "netlist")
    SICO_tomlWriteString(outFile "output_path" outPath)
    SICO_tomlWriteBool(outFile "create_view" createView)
    SICO_tomlWriteBool(outFile "pin_order_enable" form~>pinOrderBtn~>value)
    SICO_tomlWriteString(outFile "pin_order_type" form~>pinOrderType~>value)
    SICO_tomlWriteString(outFile "pin_order_file" pinControlFile)
    SICO_tomlWriteBool(outFile "brackets_replace" form~>bracketBtn~>value)
    SICO_tomlWriteString(outFile "brackets_replace_type" form~>bracketChoices~>value)
    SICO_tomlWriteBool(outFile "hierarchy_delimiter_enable" form~>hierDeliBtn~>value)
    SICO_tomlWriteString(outFile "hierarchy_delimiter" form~>hierDeliChoices~>value)
    SICO_tomlWriteBool(outFile "parasitic_coordinates" nth(0 form~>nlParInfo~>value))
    SICO_tomlWriteBool(outFile "parasitic_res_layer" nth(1 form~>nlParInfo~>value))
    SICO_tomlWriteBool(outFile "parasitic_res_dimensions" nth(2 form~>nlParInfo~>value))
    SICO_tomlWriteString(outFile "dspf_remove_instances" form~>nlRmInst~>value)
  )
)
