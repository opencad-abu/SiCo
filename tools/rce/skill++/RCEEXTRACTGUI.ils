; Compose RCE extraction option panels.

unless(and(boundp('RCEEXTRACTGUIVersion)
             symeval('RCEEXTRACTGUIVersion)=="20261019.floating.net.include.all.v1")
defmethod(makeExtopt ((inst EXTOPTGUI))
  makeExtRcTechDir(inst)
  makeExtBasicOpt(inst)
  makeExtMoreOpt(inst)
  makeExtNetSelOpt(inst)
  makeExtCellSelOpt(inst)
  makeExtFilterOpt(inst)
  makeExtRemoveFloatingNets(inst)
  inst->extOpt=makevbl('extOpt list(inst->rcTechDir
                                      inst->basicOpt
                                      inst->moreOpt
                                      list(inst->extractTopCellRow
                                           'horiz_align 'left)
                                      list(inst->nameSource
                                           'horiz_align 'left)
                                      inst->netSel
                                      inst->cellSel
                                      inst->filter
                                      inst->rmFloatNets)
                        ?f "Extract Options")

)

procedure(rceBaseGuiRevision()
  "20260909.pin.order.v1"
)

procedure(rceGuiModulesRevision()
  "20261019.floating.net.include.all.v1"
)
rceBaseGuiVersion="20260909.pin.order.v1"
set('RCEEXTRACTGUIVersion "20261019.floating.net.include.all.v1")
)
