;==============================================================================
;__Author__ : Sunny.Xia
;__Date__   : 2023/08/28
;__Version__: 0.01
;__Coding__ : SKILL++ (Cadence algebraic syntax)
;==============================================================================
;Desicrption:
;  RCE GUI callback
;==============================================================================
unless(and(isCallable('SICO_tomlRevision)
             SICO_tomlRevision()=="20260922.sico.temp.v6"
             isCallable('SICO_tomlString) isCallable('SICO_shellQuote)
             isCallable('SICO_absolutePath) isCallable('SICO_fileStem)
             isCallable('SICO_tempPath) isCallable('SICO_tempEnvironment))
  cond(
    (and(boundp('rceCommonRoot) rceCommonRoot)
      load(strcat(rceCommonRoot "/skill/SICO_toml.il")))
    (isCallable('cadLoadRelative)
      cadLoadRelative("common/skill/SICO_toml.il"))
    (t
      warn("RCECB requires RCE.ils or a configured SICO_HOME.\n"))
  )
)

unless(and(isCallable('RCE_pythonExe) isCallable('RCE_pythonEntry)
             isCallable('RCE_tomlDefaultOutput))
  cond(
    (and(boundp('rceSkillRoot) rceSkillRoot)
      load(strcat(rceSkillRoot "/skill/RCE_toml.il")))
    (isCallable('cadLoadRelative)
      cadLoadRelative("rce/skill/RCE_toml.il"))
    (t
      warn("RCECB requires the RCE runtime helper.\n"))
  )
)

procedure(rceFormValidP(form)
  SICO_lsfFormValidP(form)
)

procedure(rceFormDoneCB(form)
  when(rceFormValidP(form)
    SICO_lsfCancelFormDiscovery(form))
  t
)

procedure(rceRunCB(form)
  when(and(rceFormValidP(form) rceValidatePinOrder(form)
           rceValidateCdlRunDirectory(form))
    cadBatchDispatchStart(form 'rceStart 'rceBatchStart))
  t
)

procedure(rceRunCloseCB(form)
  when(and(rceFormValidP(form) rceValidatePinOrder(form)
           rceValidateCdlRunDirectory(form))
    when(cadBatchDispatchStart(form 'rceStart 'rceBatchStart)
      hiFormClose(form)))
  t
)

procedure(timeFormatter()
  let((time hms)
    time=parseString(getCurrentTime() " ")
    hms=parseString(nth(2 time) ":")
    strcat(nth(0 hms) nth(1 hms) "-" nth(0 time) nth(1 time) "-" nth(3 time))
);let
)

procedure(rceFrontendRevision()
  "20261019.floating.net.include.all.v1"
)

procedure(rceFlowAuditRevision()
  "20260911.flow.audit.v1"
)

procedure(rceNetlistViewRevision()
  "20260911.corner.text.views.v1"
)

procedure(rceAbsolutePathRevision()
  "20260812.toml.absolute.paths.v1"
)

procedure(rceUsesCadTempPath()
  t
)

procedure(rceCustomSvrfRevision()
  "20260813.custom.svrf.common.v1"
)

procedure(rceCdlIncludeRevision()
  "20260812.cdl.include.v2"
)

procedure(rceCallbackModulesRevision()
  "20261019.floating.net.include.all.v1"
)
