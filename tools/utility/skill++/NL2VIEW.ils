; Generated by tools/utility/skill_loader.py --write; edit the manifest/sources.
; Source-only. Per-file contracts retain successful members across retries.
let((entryDirectory)
  entryDirectory=strcat("/" buildString(reverse(cdr(reverse(
    parseString(simplifyFilename(get_filename(piport) t) "/")))) "/"))
  load(strcat(entryDirectory "/../../../scripts/sicoSkillLoader.ils"))
  load(strcat(entryDirectory "/../../../scripts/sicoSource.il"))
  SICO_sourceRequire("nl2view" "bfa34d477bea1f18da2283f785c0b65e81e5ec4f1a9b3e3ac81aa4204931f4cd" '(
    ("tools/utility/skill" "nl2view.il" "49f3d2ddc0dfbde02ec9f30da64b0270229379e0237a51ed843145c115600b04"
      (cadNl2ViewBrand cadNl2ViewExitCleanup cadNl2ViewInitializeRuntime cadNl2ViewDefaultView
       cadNl2ViewFormatArgument cadNl2ViewSetStatus cadNl2ViewFormatCB cadNl2ViewSourceCB
       cadNl2ViewToolsRoot cadNl2ViewNonEmpty cadNl2ViewSessionLibraryPath cadNl2ViewCommand
       cadNl2ViewDataHandler cadNl2ViewErrorHandler cadNl2ViewPostFunc cadNl2ViewApplyCB
       cadNl2ViewCloseCB cadNl2ViewCreateForm cadDisplayNl2ViewForm cadNl2ViewRevision)
      ()
      (sicoNl2ViewVersion)
      ()
      ())
  ))
)
