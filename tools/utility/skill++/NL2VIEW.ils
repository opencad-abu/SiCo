; Generated by tools/utility/skill_loader.py --write; edit the manifest/sources.
; Source-only. Per-file contracts retain successful members across retries.
let((entryDirectory)
  entryDirectory=strcat("/" buildString(reverse(cdr(reverse(
    parseString(simplifyFilename(get_filename(piport) t) "/")))) "/"))
  load(strcat(entryDirectory "/../../../scripts/sicoSkillLoader.ils"))
  load(strcat(entryDirectory "/../../../scripts/sicoSource.il"))
  SICO_sourceRequire("nl2view" "13831a468f82643b9b508b536c8814224ad2a75a286364fd448a632ee0ef70bf" '(
    ("tools/utility/skill" "nl2view.il" "e0f549889a4bd834a44a8e6f974f5b8ba4d059e6adfd20457bf785a84b2f8cf1"
      (cadNl2ViewBrand cadNl2ViewExitCleanup cadNl2ViewInitializeRuntime cadNl2ViewDefaultView
       cadNl2ViewFormatArgument cadNl2ViewSetStatus cadNl2ViewFormatCB cadNl2ViewSourceCB
       cadNl2ViewToolsRoot cadNl2ViewNonEmpty cadNl2ViewSessionLibraryPath cadNl2ViewCommand
       cadNl2ViewDataHandler cadNl2ViewErrorHandler cadNl2ViewPostFunc cadNl2ViewApplyCB
       cadNl2ViewCloseCB cadNl2ViewCreateForm cadDisplayNl2ViewForm cadNl2ViewRevision)
      ()
      (sicoNl2ViewVersion)
      ())
  ))
)
