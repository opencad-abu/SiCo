; Generated by tools/utility/skill_loader.py --write; edit the manifest/sources.
; Source-only. Per-file contracts retain successful members across retries.
let((entryDirectory)
  entryDirectory=strcat("/" buildString(reverse(cdr(reverse(
    parseString(simplifyFilename(get_filename(piport) t) "/")))) "/"))
  load(strcat(entryDirectory "/../../../scripts/sicoSkillLoader.ils"))
  load(strcat(entryDirectory "/../../../scripts/sicoSource.il"))
  SICO_sourceRequire("lsf" "6c9149c118dd2c6c8b29cb45720edf4f7b69b1382be9d37ae34c5a4480a585b0" '(
    ("tools/common/skill" "SICO_lsf.il" "9a3e7efa5aa5aedc2ce6cb9185d252e31bbe16fd452ab035cd818996fe87f746"
      (SICO_lsfRevision SICO_lsfFormValidP SICO_lsfUniqueHosts SICO_lsfLocalHost SICO_lsfAutoHost)
      ()
      (sicoCADlsfModulesVersion)
      ()
      ())
    ("tools/common/skill" "SICO_lsfSelection.il" "fae42f6bc0d2791e9d8d8e35e264c4b13afc0a2d61b9f9dd1e9de8caf3d8c4db"
      (SICO_lsfPreferredQueue SICO_lsfSetPreferredValues SICO_lsfClearPreferredValues
       SICO_lsfUpdateQueueField SICO_lsfApplyQueues SICO_lsfPreferredHost SICO_lsfClearVerifiedSelection
       SICO_lsfSelectionValidP SICO_lsfValidateSelection SICO_lsfApplyHosts)
      ()
      (sicoCADlsfSelectionModulesVersion)
      ()
      ())
    ("tools/common/skill" "SICO_lsfProtocol.il" "7f88aa60cdb984ab922ab8d524e57e982747061570458667635ab73522c9be63"
      (SICO_lsfProtocolRecords SICO_lsfReadQueues SICO_lsfReadHosts)
      ()
      (sicoCADlsfProtocolModulesVersion)
      ()
      ())
    ("tools/common/skill" "SICO_lsfProcess.il" "5251c27884ffbcd5ba9c3a598c8195e25db03d92db980d23f4e3378f31b2b07f"
      (SICO_lsfDeleteFile SICO_lsfSignalSucceededP SICO_lsfCancelState SICO_lsfCancelFormDiscovery
       SICO_lsfStopAll SICO_lsfRegisterExitCleanup SICO_lsfBeginProcess)
      ()
      (sicoCADlsfProcessModulesVersion)
      ()
      ())
    ("tools/common/skill" "SICO_lsfCommands.il" "f8f083bf1d259f27651e273f6ae64138b10161570d19bf692cdedb7c64b30cd5"
      (SICO_lsfInstalledPython SICO_lsfPythonExe SICO_lsfDiscoveryScript SICO_lsfDiscoveryPath
       SICO_lsfDiscoveryCommand SICO_lsfNormalizeCpu SICO_lsfSelectedHost SICO_lsfMaxCpu
       SICO_lsfQueueInteractiveP SICO_lsfWrapCommand SICO_lsfCancelCommand)
      ()
      (sicoCADlsfCommandsModulesVersion)
      ()
      ())
    ("tools/common/skill" "SICO_lsfHosts.il" "3b3dd3e83b5ac2a7318f62a1187f1fdd6ec990a6463b48601e2b1e3f7aae6e38"
      (SICO_lsfDiscoveryDataHandler SICO_lsfDiscoveryErrHandler SICO_lsfDiscoveryPostFunc
       SICO_lsfStartHostDiscovery)
      ()
      (sicoCADlsfHostsModulesVersion)
      ()
      ())
    ("tools/common/skill" "SICO_lsfQueues.il" "2f73c8fd4e99502dff8dab1c1f8d4610339b0fa14f747d323332b00c68b394f0"
      (SICO_lsfQueueDiscoveryDataHandler SICO_lsfQueueDiscoveryErrHandler SICO_lsfQueueDiscoveryPostFunc
       SICO_lsfStartQueueDiscovery)
      ()
      (sicoCADlsfQueuesModulesVersion)
      ()
      ())
    ("tools/common/skill" "SICO_lsfChoices.il" "91d84c731d69071ff52142ddcc91e10f26e244aeb2560c61886e909c17971f2d"
      (SICO_lsfQueueChoicesCB SICO_lsfChoicesCB SICO_lsfInitializeRuntime SICO_lsfModulesRevision)
      ((SICO_lsfModulesRevision "20260924.flow.environment.v3"))
      (sicoCADlsfChoicesModulesVersion)
      ()
      ())
    ("tools/common/skill" "SICO_lsfMonitor.il" "8165ab7eb998077df22e757edc51da4dedb6ac5aafc3c8fe328751766b346660"
      (SICO_lsfMonitorRevision SICO_lsfMonitorButtonIcon SICO_lsfMonitorDataHandler
       SICO_lsfMonitorErrHandler SICO_lsfMonitorReadSelection SICO_lsfMonitorPostFunc
       SICO_lsfMonitorCancelCid SICO_lsfMonitorCancelForm SICO_lsfMonitorStopAll
       SICO_lsfMonitorRegisterExitCleanup SICO_lsfMonitorLaunchCommand SICO_lsfMonitorStart
       SICO_lsfMonitorStartSelector SICO_lsfMonitorInitializeRuntime)
      ((SICO_lsfMonitorRevision "20260924.sico.monitor.environment.v3"))
      (sicoLsfMonitorVersion)
      ()
      ())
  ))
)
