procedure(mtsRuntimeSourceSymbol()
let((sourceLib sourceCell transferLib transferCell reportPort srcCV dstCV)
  sourceLib = getShellEnvVar("MTS_SOURCE_LIB")
  sourceCell = getShellEnvVar("MTS_SOURCE_CELL")
  transferLib = getShellEnvVar("MTS_TRANSFER_LIB")
  transferCell = getShellEnvVar("MTS_TRANSFER_CELL")
  reportPort = outfile(getShellEnvVar("MTS_TRANSFER_REPORT") "w")
  fprintf(reportPort "stage=source\n")
  fprintf(reportPort "pid=%L\n" getShellEnvVar("MTS_PROCESS_PID"))
  fprintf(reportPort "cds_lib=%s\n" getShellEnvVar("CDS_LIB"))
  fprintf(reportPort "source=%s/%s/symbol\n" sourceLib sourceCell)
  fprintf(reportPort "transfer=%s/%s/symbol\n" transferLib transferCell)
  srcCV = dbOpenCellViewByType(sourceLib sourceCell "symbol" "schematicSymbol" "r")
  unless(srcCV
    close(reportPort)
    error("MTS source symbol cannot be opened")
  )
  fprintf(reportPort "source_terminals=%L\n" foreach(mapcar terminal srcCV~>terminals terminal~>name))
  dstCV = dbCopyCellView(srcCV transferLib transferCell "symbol" nil nil t)
  unless(dstCV
    dbClose(srcCV)
    close(reportPort)
    error("MTS source symbol copy failed")
  )
  fprintf(reportPort "transfer_terminals=%L\n" foreach(mapcar terminal dstCV~>terminals terminal~>name))
  fprintf(reportPort "copy_result=t\n")
  dbClose(dstCV)
  dbClose(srcCV)
  close(reportPort)
)
t)

procedure(mtsRuntimeTargetSymbol()
let((targetLib targetCell transferLib transferCell reportPort srcCV dstCV overwrite targetExisted)
  targetLib = getShellEnvVar("MTS_TARGET_LIB")
  targetCell = getShellEnvVar("MTS_TARGET_CELL")
  transferLib = getShellEnvVar("MTS_TRANSFER_LIB")
  transferCell = getShellEnvVar("MTS_TRANSFER_CELL")
  overwrite = getShellEnvVar("MTS_TARGET_OVERWRITE")=="1"
  targetExisted = if(ddGetObj(targetLib targetCell "symbol") then t else nil)
  reportPort = outfile(getShellEnvVar("MTS_TRANSFER_REPORT") "w")
  fprintf(reportPort "stage=target\n")
  fprintf(reportPort "pid=%L\n" getShellEnvVar("MTS_PROCESS_PID"))
  fprintf(reportPort "cds_lib=%s\n" getShellEnvVar("CDS_LIB"))
  fprintf(reportPort "target=%s/%s/symbol\n" targetLib targetCell)
  fprintf(reportPort "transfer=%s/%s/symbol\n" transferLib transferCell)
  fprintf(reportPort "overwrite=%L\n" overwrite)
  fprintf(reportPort "target_existed=%L\n" targetExisted)
  srcCV = dbOpenCellViewByType(transferLib transferCell "symbol" "schematicSymbol" "r")
  unless(srcCV
    close(reportPort)
    error("MTS transfer symbol cannot be opened")
  )
  fprintf(reportPort "transfer_terminals=%L\n" foreach(mapcar terminal srcCV~>terminals terminal~>name))
  dstCV = dbCopyCellView(srcCV targetLib targetCell "symbol" nil nil overwrite)
  unless(dstCV
    dbClose(srcCV)
    close(reportPort)
    error("MTS target symbol copy failed")
  )
  fprintf(reportPort "target_terminals=%L\n" foreach(mapcar terminal dstCV~>terminals terminal~>name))
  fprintf(reportPort "copy_result=t\n")
  dbClose(dstCV)
  dbClose(srcCV)
  close(reportPort)
)
t)
