simulator('hspiceD)
design("sxTest" "bufferx1" "schematic" "r")
resultsDir(getShellEnvVar("MTS_PROBE_RESULTS"))
envOption('setTopLevelAsSubckt t)
temp(27)
option('scale 0.9)
printf("MTS_P3_CREATE_BEGIN\n")
mtsNetlist = createNetlist(?recreateAll t ?display nil)
if(mtsNetlist then printf("MTS_P3_CREATE_RAW=%s\n" mtsNetlist) else printf("MTS_P3_CREATE_ERROR\n"))
exit()
