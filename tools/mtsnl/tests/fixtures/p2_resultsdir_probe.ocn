envSetVal("asimenv.startup" "projectDir" 'string getShellEnvVar("MTS_PROBE_PROJECT"))
simulator('spectre)
design("sxTest" "bufferx1" "schematic" "r")
resultsDir(getShellEnvVar("MTS_PROBE_RESULTS"))
envOption('setTopLevelAsSubckt t)
temp(27)
printf("MTS_P2_RESULTSDIR_BEGIN\n")
mtsNetlist = createNetlist(?recreateAll t ?display nil)
if(mtsNetlist then printf("MTS_P2_RESULTSDIR_RAW=%s\n" mtsNetlist) else printf("MTS_P2_RESULTSDIR_ERROR\n"))
exit()
