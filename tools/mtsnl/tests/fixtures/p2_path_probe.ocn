envSetVal("asimenv.startup" "projectDir" 'string getShellEnvVar("MTS_PROBE_PROJECT"))
envSetVal("asimenv.startup" "resultsDir" 'string getShellEnvVar("MTS_PROBE_RESULTS"))
simulator('spectre)
design("sxTest" "bufferx1" "schematic" "r")
envOption('setTopLevelAsSubckt t)
temp(27)
printf("MTS_P2_PATH_BEGIN\n")
mtsNetlist = createNetlist(?recreateAll t ?display nil)
if(mtsNetlist then printf("MTS_P2_PATH_RAW=%s\n" mtsNetlist) else printf("MTS_P2_PATH_ERROR\n"))
exit()
