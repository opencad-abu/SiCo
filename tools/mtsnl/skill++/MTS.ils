; Generated by tools/utility/skill_loader.py --write; edit the manifest/sources.
; Source-only. Per-file contracts retain successful members across retries.
let((entryDirectory)
  entryDirectory=strcat("/" buildString(reverse(cdr(reverse(
    parseString(simplifyFilename(get_filename(piport) t) "/")))) "/"))
  load(strcat(entryDirectory "/../../../scripts/sicoSkillLoader.ils"))
  load(strcat(entryDirectory "/../../../scripts/sicoSource.il"))
  SICO_sourceRequire("mts" "aa9fb96bef425cce57f03f68523974e6444d5b2be670fec2268518faf28b4698" '(
    ("tools/mtsnl/skill" "MTS_netlistor.il" "491363489bb420f803afb03a99c4b63ad207fcc336b1513ba4f3beb267fae609"
      (mtsNetlistorRevision mtsNetlistorBrand mtsNetlistorOaNameP mtsNetlistorParseOpenView
       mtsNetlistorSessionLibraryP mtsNetlistorHandleOpenView mtsNetlistorDataHandler
       mtsNetlistorShellQuote mtsNetlistorJsonEscape mtsNetlistorProcStartTime mtsNetlistorReadToken
       mtsNetlistorDigestValidP mtsNetlistorTargetLibraries mtsNetlistorWriteSession
       mtsNetlistorToolsRoot mtsNetlistorModuleRoot mtsNetlistorLaunchCommand mtsNetlistorStopAll
       mtsNetlistorRunningProcess mtsNetlistorPostFunc mtsNetlistorStart mtsNetlistorInitializeRuntime)
      ((mtsNetlistorRevision "20261024.sico.mts.launcher.v12"))
      (mtsNetlistorVersion)
      ()
      ())
  ))
)
