; Generated by tools/utility/skill_loader.py --write; edit the manifest/sources.
; Source-only. Per-file contracts retain successful members across retries.
let((entryDirectory)
  entryDirectory=strcat("/" buildString(reverse(cdr(reverse(
    parseString(simplifyFilename(get_filename(piport) t) "/")))) "/"))
  load(strcat(entryDirectory "/../../../scripts/sicoSkillLoader.ils"))
  load(strcat(entryDirectory "/../../../scripts/sicoSource.il"))
  SICO_sourceRequire("mts" "8db06c7a32aedf1db0c46d00dcac3fcb3599b2eb04f46626715b33909aea7515" '(
    ("tools/mtsnl/skill" "MTS_netlistor.il" "0a5c51d506b2235f65a43217285422f7ee8165a0ff93502ace760cf81aa01712"
      (mtsNetlistorRevision mtsNetlistorBrand mtsNetlistorOaNameP mtsNetlistorParseOpenView
       mtsNetlistorSessionLibraryP mtsNetlistorHandleOpenView mtsNetlistorDataHandler
       mtsNetlistorShellQuote mtsNetlistorJsonEscape mtsNetlistorProcStartTime mtsNetlistorReadToken
       mtsNetlistorDigestValidP mtsNetlistorTargetLibraries mtsNetlistorWriteSession
       mtsNetlistorToolsRoot mtsNetlistorModuleRoot mtsNetlistorLaunchCommand mtsNetlistorStopAll
       mtsNetlistorRunningProcess mtsNetlistorPostFunc mtsNetlistorStart mtsNetlistorInitializeRuntime)
      ((mtsNetlistorRevision "20261022.sico.mts.launcher.v9"))
      (mtsNetlistorVersion)
      ())
  ))
)
