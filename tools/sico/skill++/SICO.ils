; Generated by tools/utility/skill_loader.py --write; edit the manifest/sources.
; Source-only. Per-file contracts retain successful members across retries.
set('sicoLoaderVersion nil)
let((entryDirectory)
  entryDirectory=strcat("/" buildString(reverse(cdr(reverse(
    parseString(simplifyFilename(get_filename(piport) t) "/")))) "/"))
  load(strcat(entryDirectory "/../../../scripts/sicoSkillLoader.ils"))
  load(strcat(entryDirectory "/../../ai/skill++/AI_shared.ils"))
  set('sicoRoot strcat(SICO_sourceRoot() "/tools/sico"))
  SICO_sourceRequire("sico" "66e28283505908c71868b410968e88a240a2043b062d2cf5e2399290f286f501" '(
    ("tools/ai/skill" "AI_entry_project.il" "fc3ecc06f5c3f876e7ad6f0c6e9e88c3b80cc15b5e6f49a18c3a9622fde0511b"
      (sicoProjectReply aiEntryProjectName aiEntryProjectRead)
      ()
      ()
      ())
    ("tools/ai/skill" "AI_copilot_literals.il" "374395bc25219c68c75f0ea4f337cc445ca74a0ae953fccd74b4389745e85c90"
      (aiCopilotHex aiCopilotLiteral aiCopilotDecode)
      ()
      ()
      ())
    ("tools/ai/skill" "AI_copilot_results.il" "5abb5a26ffb14ff84f60fc7b6dff21d62fd316235005e2fbfb9af6c4618b2f5b"
      (aiCopilotBindResults aiCopilotResultCheck aiCopilotAnalysisPageCall aiCopilotAnalysisCapture)
      ()
      ()
      ())
    ("tools/ai/skill" "AI_copilot_targets.il" "9d26ab4fecdf94f0ae5eeba8fdb63008e2383487e35a63dfff4824c299a9ecc6"
      (aiCopilotTargetFamily aiCopilotJsonList aiCopilotSourcelessFunction aiCopilotSourcelessFunctions
       aiCopilotOpenWindows aiCopilotOpenTargets aiCopilotListTargets aiCopilotListLibraries
       aiCopilotListCells aiCopilotListViews aiCopilotOpenTarget aiCopilotInspectSelected
       aiCopilotHighlightObject aiCopilotListObjects aiCopilotListObjectWindows aiCopilotListWindows
       aiCopilotExpandHome)
      ()
      ()
      ())
    ("tools/ai/skill" "AI_copilot_circuit.il" "4f8117046b25ec86fb7442b9dc5821e054b799140135428ff77a00e194dc875d"
      (aiCopilotFailureStage aiCopilotReject aiCopilotMutatingFunction aiCopilotEnterFunction
       aiCopilotSourceCheck aiCopilotTaskCheck aiCopilotTaskBindingReply aiCopilotOwner
       aiCopilotRetainedCheck aiCopilotDescribe aiCopilotFinal aiCopilotDispatch
       aiCopilotSynchronousCaptureP aiCopilotCaptureRevision aiCopilotCaptureDispatch
       aiCopilotAttachCapturedOutput sicoCircuitReply)
      ((aiCopilotCaptureRevision "20261021.ai.circuit.capture.v7"))
      ()
      ())
    ("tools/sico/skill" "SICO_entry.il" "309191a9720d1ae6203920d845e79dc3aba148a0cd45092eb4a40f3f6ad6ac28"
      (sicoEntryObservation sicoEntryRef sicoEntryRead)
      ()
      ()
      ())
    ("tools/sico/skill" "SICO_diagnostics.il" "fdae3ecf464847f20dc8cc9c24c895c24ce6a0049c81d62504ff59f6defbb90c"
      (sicoDiagnostic sicoConfigureDiagnostics sicoDiagnosticsRevision)
      ((sicoDiagnosticsRevision "20260921.sico.diagnostics.v1"))
      (sicoDiagnosticsVersion)
      ())
    ("tools/sico/skill" "SICO_binding.il" "f4d6d5a6d212db256a3721d591d663580bb40bfd61d80980e268210695c3fda4"
      (sicoBindingRevision sicoBindingSamePath sicoNativeRequest aiCopilotResolveResources
       sicoNativeResourceCheck sicoNativeRecord sicoNativeOutput sicoNativeGone sicoNativePostInstall
       sicoNativePoll sicoInstallNativeBindings)
      ((sicoBindingRevision "20261020.sico.binding.v2"))
      ()
      ())
    ("tools/sico/skill" "SICO_context.il" "22e5d40131f2f8db1cbea981027eb4ee1cbe50e1bfab7cafb416058c858fab8a"
      (sicoRequestIdP sicoTrace sicoProjectContextJson sicoAdeCellJson sicoContextJson sicoAssistantReply
       sicoIpcWrite sicoWriteReply sicoReadReply sicoRequestBody sicoRequest sicoDispatch sicoDataPart
       sicoData sicoError sicoExit sicoConnect sicoDisconnect sicoContextRevision)
      ((sicoContextRevision "20261020.sico.context.v3"))
      (sicoContextVersion)
      ())
    ("tools/sico/skill" "SICO_source.il" "fb5944990b9e87bf88a6c747a531788f74abb16787c395cbf2c9598e02c8154f"
      (sicoSourceRead sicoSourceObservation)
      ()
      ()
      ())
    ("tools/sico/skill" "SICO_ade.il" "baa774c4cbe95b6fe1d76f86ae380360217f3a821c0b0da197c3944f8c96c372"
      (sicoReadText sicoReadArray sicoReadLimit sicoReadNames sicoAdeOutputJson sicoAdeTestJson
       sicoAdeSetupJson sicoAdeHistoryRow sicoAdeHistoryJson sicoAdeDispatch sicoAdeRevision)
      ((sicoAdeRevision "20260921.sico.ade.v1"))
      (sicoAdeVersion)
      ())
    ("tools/sico/skill" "SICO_sessions.il" "4544c4e96f24f4c895bd409551a60259534cfa0b91c4ec82847b35ae7b56ddd8"
      (sicoSessionLive sicoSessionForWindow sicoBindSession sicoSessionTarget sicoNewSession
       sicoSessionNotice sicoSessionsRevision)
      ((sicoSessionsRevision "20260921.sico.sessions.v1"))
      (sicoSessionsVersion)
      ())
    ("tools/sico/skill" "SICO_launcher.il" "57749be6a4ddf685eab8ab98d91f60a6f818ad922984322789be47ee50880046"
      (sicoEnv sicoQuote sicoLaunchCommand sicoEnsureBridge sicoReconnectBridge sicoFinishReconnect
       sicoReconnectSession sicoPlaceCiw sicoPlaceLaunchedCiw sicoShow sicoStopDesktop
       sicoRequestShutdown sicoExitCleanup sicoRegisterExitCleanup sicoLauncherRevision)
      ((sicoLauncherRevision "20261020.sico.launcher.v7"))
      (sicoLauncherVersion)
      ())
    ("tools/sico/skill" "SICO_registration.il" "4161aeaf2a1ae9412209dc3ed886644ed2e5f8dded801263cc53508c7c5baedb"
      (sicoRegisterPlatform sicoSchedulePlatformRegistration)
      ()
      (sicoRegistrationVersion)
      ())
    ("tools/sico/skill" "SICO_menus.il" "44b7dc08e6075022d6c6dd511a202c53d66a1807f7f6dc1b1b8f1bc57cbf1cc6"
      (sicoWindowForSession sicoWindowForResult sicoMenuCommand sicoFromMenu sicoHistoryMenu
       sicoMenuArgument sicoResultsMenu sicoInstallAdeMenus sicoAdeWindowP sicoAdeMenuBinding
       sicoAdeWindowMenu sicoAdeMenuPosition sicoInstallAdeWindowMenus sicoAdeMenuPoll
       sicoStartAdeMenuPoll sicoMenusRevision)
      ((sicoMenusRevision "20261020.sico.menus.v2"))
      (sicoMenusVersion)
      ())
    ("tools/sico/skill" "SICO_desktop.il" "a33d34f1d40889e30f26cf92bafb868a919ed6893d6abee554256c801cdc33e1"
      (sicoDesktopRevision sicoDesktopFind sicoDesktopAttach sicoDesktopLaunch sicoDesktopWake)
      ((sicoDesktopRevision "20261021.sico.desktop.v2"))
      ()
      ())
    ("tools/sico/skill" "SICO_ask_queue.il" "fc1b1ddaff7edcce391ecf36cda5b338c7c46f260ae01ad724dfb99c9e1724b4"
      (sicoAskAvailable sicoAskEnqueue sicoAskPump sicoAskSettled sicoAskQuery sicoAskRestoreUnknown)
      ()
      ()
      ())
    ("tools/sico/skill" "SICO_quick.il" "ee5bb4ba500215d88f59f0d8b04b3dcf526805c3abb1a641246b84a399930da2"
      (sicoQuickSource sicoQuickPointP sicoQuickAnchor sicoQuickAnchorJson sicoQuickSend sicoQuickAsk
       sicoQuickObjects sicoQuickSubmit sicoQuickAcceptedHost sicoQuickRejectedHost sicoQuickUnknownHost
       sicoQuickWake sicoQuickHostLine sicoQuickHostData sicoQuickHostExit sicoQuickData
       sicoQuickHostPending sicoQuickAccepted sicoQuickRejected sicoQuickExit sicoQuickChildExit
       sicoQuickRevision)
      ((sicoQuickRevision "20261021.sico.quick.v7"))
      (sicoQuickVersion)
      ())
    ("tools/sico/skill" "SICO_rmb.il" "125079bed6561af4186c92667d6c218eaf53732650f492d0e6daabba0bfbc55d"
      (sicoAskIcon sicoEditorMenuCommand sicoSchematicMenus sicoPrepareSchematicMenu
       sicoInstallSchematicRmb sicoLayoutMenuItem sicoInstallLayoutRmb sicoRegisterRmbTrigger
       sicoInstallEditorMenus sicoRmbRevision)
      ((sicoRmbRevision "20260921.sico.rmb.v2"))
      (sicoRmbVersion)
      ())
  ))
  SICO_sourceInitialize("sico" '(sicoInstallAdeMenus sicoInstallEditorMenus sicoInstallNativeBindings sicoSchedulePlatformRegistration sicoPlaceLaunchedCiw))
  set('sicoLoaderVersion sicoLoaderRevision())
)
